* SPDX-FileCopyrightText: 2026 Christoph Maier
* SPDX-License-Identifier: Apache-2.0
*
* tb_ref_tran: start-up check of a reference-current core by supply ramp, at one
* model-library section (@CORNER@).
* Template: scripts/run_sims.py replaces @PDK_ROOT@ @PDK@ @CORNER@ @OUT@ @NETLIST@ @DUT@.
*
* vdd = V(ramp) * V(vfin): 0 V -> vfin, linear ramp, then held.
* en_3v3 is tied to vdd (enabled from the start), en_3v3_b = 0 V.
* Load: NMOS diode sky130_fd_pr__nfet_g5v0d10v5 W/L = 20/1 (V_GS ~ 0.7..0.9 V at 5 uA),
*       iout measured through the 0 V source Vmeas.
* Runs: temperature -40 / 27 / 125 C  x  vfin = 3.0 / 3.6 V  x  ramp 10 us (fast) and
*       1 ms (slow); simulated to 3x the ramp time.
.lib @PDK_ROOT@/@PDK@/libs.tech/ngspice/sky130.lib.spice @CORNER@
.include @NETLIST@

Vfin  vfin 0 3.3
Vramp ramp 0 PWL(0 0 10u 1)
Bvdd  vdd  0 V = V(ramp)*V(vfin)
XDUT vdd 0 iout vdd 0 @DUT@
Vmeas iout nd 0
XLD  nd nd 0 0 sky130_fd_pr__nfet_g5v0d10v5 w=20 l=1 nf=2

.control
set wr_singlescale
set wr_vecnames
foreach tc -40 27 125
  option temp = $tc
  foreach vf 3.0 3.6
    alter Vfin dc = $vf
    alter @Vramp[pwl] = [ 0 0 10u 1 ]
    tran 20n 30u
    let iout = i(Vmeas)
    let vddv = v(vdd)
    wrdata @OUT@_fast_t{$tc}_v{$vf}.txt iout vddv
    alter @Vramp[pwl] = [ 0 0 1m 1 ]
    tran 2u 3m
    let iout = i(Vmeas)
    let vddv = v(vdd)
    wrdata @OUT@_slow_t{$tc}_v{$vf}.txt iout vddv
  end
end
.endc
.end
