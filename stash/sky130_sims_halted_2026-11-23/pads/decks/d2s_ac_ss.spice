* d2s_ac_ss: D2S core closed-loop AC, corner ss
* SPDX-FileCopyrightText: 2026 Christoph Maier
* SPDX-License-Identifier: Apache-2.0
* sky130 pre-layout schematic simulation (feasibility, not sign-off).
* Generated by scripts/gen_decks.py; regenerate rather than edit. Run from decks/: ngspice -b <deck>
* vd = 0 (dc), ac 1 on vd; vref = 1.26 V; load (1 kOhm to vref, or open) || Cl (10 / 100 / 300 pF).
* Ideal |pad / vd| = 0.5 (-6.02 dB).
.lib /foss/pdks/sky130A/libs.tech/ngspice/sky130.lib.spice ss
.include ../netlists/units_sky130.spice
.include ../netlists/d2s_core_sky130.spice
Vdd vdd 0 3.3
Vref vref 0 1.26
Vd vd 0 dc 0 ac 1
* vinp = vref + vd/2, vinn = vref - vd/2 (input CM = vref = vcm line)
Ep vinp vref vd 0 0.5
En vinn vref vd 0 -0.5
Iref vdd iref 5u
X1 vdd 0 vinp vinn vref pad iref d2s_core_sky130
Rl pad vref 1k
Cl pad 0 100p
.control
set wr_singlescale
set wr_vecnames
option numdgt=8
option temp=-40
alter vdd dc=3.0
alter rl 1000
alter cl 1e-11
ac dec 40 100 1G
wrdata ../build/d2s_ac_ss_T-40_V3_r1k_cl10p.txt mag(v(pad)) ph(v(pad))
destroy all
alter cl 1e-10
ac dec 40 100 1G
wrdata ../build/d2s_ac_ss_T-40_V3_r1k_cl100p.txt mag(v(pad)) ph(v(pad))
destroy all
alter cl 3e-10
ac dec 40 100 1G
wrdata ../build/d2s_ac_ss_T-40_V3_r1k_cl300p.txt mag(v(pad)) ph(v(pad))
destroy all
alter rl 1e+09
alter cl 1e-11
ac dec 40 100 1G
wrdata ../build/d2s_ac_ss_T-40_V3_open_cl10p.txt mag(v(pad)) ph(v(pad))
destroy all
alter cl 1e-10
ac dec 40 100 1G
wrdata ../build/d2s_ac_ss_T-40_V3_open_cl100p.txt mag(v(pad)) ph(v(pad))
destroy all
alter cl 3e-10
ac dec 40 100 1G
wrdata ../build/d2s_ac_ss_T-40_V3_open_cl300p.txt mag(v(pad)) ph(v(pad))
destroy all
alter rl 1k
op
wrdata ../build/d2s_op_ss_T-40_V3.txt v(pad) i(vdd) @m.x1.xa.xop.msky130_fd_pr__pfet_g5v0d10v5[id] @m.x1.xa.xon.msky130_fd_pr__nfet_g5v0d10v5[id]
destroy all
alter vdd dc=3.3
alter rl 1000
alter cl 1e-11
ac dec 40 100 1G
wrdata ../build/d2s_ac_ss_T-40_V3.3_r1k_cl10p.txt mag(v(pad)) ph(v(pad))
destroy all
alter cl 1e-10
ac dec 40 100 1G
wrdata ../build/d2s_ac_ss_T-40_V3.3_r1k_cl100p.txt mag(v(pad)) ph(v(pad))
destroy all
alter cl 3e-10
ac dec 40 100 1G
wrdata ../build/d2s_ac_ss_T-40_V3.3_r1k_cl300p.txt mag(v(pad)) ph(v(pad))
destroy all
alter rl 1e+09
alter cl 1e-11
ac dec 40 100 1G
wrdata ../build/d2s_ac_ss_T-40_V3.3_open_cl10p.txt mag(v(pad)) ph(v(pad))
destroy all
alter cl 1e-10
ac dec 40 100 1G
wrdata ../build/d2s_ac_ss_T-40_V3.3_open_cl100p.txt mag(v(pad)) ph(v(pad))
destroy all
alter cl 3e-10
ac dec 40 100 1G
wrdata ../build/d2s_ac_ss_T-40_V3.3_open_cl300p.txt mag(v(pad)) ph(v(pad))
destroy all
alter rl 1k
op
wrdata ../build/d2s_op_ss_T-40_V3.3.txt v(pad) i(vdd) @m.x1.xa.xop.msky130_fd_pr__pfet_g5v0d10v5[id] @m.x1.xa.xon.msky130_fd_pr__nfet_g5v0d10v5[id]
destroy all
alter vdd dc=3.6
alter rl 1000
alter cl 1e-11
ac dec 40 100 1G
wrdata ../build/d2s_ac_ss_T-40_V3.6_r1k_cl10p.txt mag(v(pad)) ph(v(pad))
destroy all
alter cl 1e-10
ac dec 40 100 1G
wrdata ../build/d2s_ac_ss_T-40_V3.6_r1k_cl100p.txt mag(v(pad)) ph(v(pad))
destroy all
alter cl 3e-10
ac dec 40 100 1G
wrdata ../build/d2s_ac_ss_T-40_V3.6_r1k_cl300p.txt mag(v(pad)) ph(v(pad))
destroy all
alter rl 1e+09
alter cl 1e-11
ac dec 40 100 1G
wrdata ../build/d2s_ac_ss_T-40_V3.6_open_cl10p.txt mag(v(pad)) ph(v(pad))
destroy all
alter cl 1e-10
ac dec 40 100 1G
wrdata ../build/d2s_ac_ss_T-40_V3.6_open_cl100p.txt mag(v(pad)) ph(v(pad))
destroy all
alter cl 3e-10
ac dec 40 100 1G
wrdata ../build/d2s_ac_ss_T-40_V3.6_open_cl300p.txt mag(v(pad)) ph(v(pad))
destroy all
alter rl 1k
op
wrdata ../build/d2s_op_ss_T-40_V3.6.txt v(pad) i(vdd) @m.x1.xa.xop.msky130_fd_pr__pfet_g5v0d10v5[id] @m.x1.xa.xon.msky130_fd_pr__nfet_g5v0d10v5[id]
destroy all
option temp=27
alter vdd dc=3.0
alter rl 1000
alter cl 1e-11
ac dec 40 100 1G
wrdata ../build/d2s_ac_ss_T27_V3_r1k_cl10p.txt mag(v(pad)) ph(v(pad))
destroy all
alter cl 1e-10
ac dec 40 100 1G
wrdata ../build/d2s_ac_ss_T27_V3_r1k_cl100p.txt mag(v(pad)) ph(v(pad))
destroy all
alter cl 3e-10
ac dec 40 100 1G
wrdata ../build/d2s_ac_ss_T27_V3_r1k_cl300p.txt mag(v(pad)) ph(v(pad))
destroy all
alter rl 1e+09
alter cl 1e-11
ac dec 40 100 1G
wrdata ../build/d2s_ac_ss_T27_V3_open_cl10p.txt mag(v(pad)) ph(v(pad))
destroy all
alter cl 1e-10
ac dec 40 100 1G
wrdata ../build/d2s_ac_ss_T27_V3_open_cl100p.txt mag(v(pad)) ph(v(pad))
destroy all
alter cl 3e-10
ac dec 40 100 1G
wrdata ../build/d2s_ac_ss_T27_V3_open_cl300p.txt mag(v(pad)) ph(v(pad))
destroy all
alter rl 1k
op
wrdata ../build/d2s_op_ss_T27_V3.txt v(pad) i(vdd) @m.x1.xa.xop.msky130_fd_pr__pfet_g5v0d10v5[id] @m.x1.xa.xon.msky130_fd_pr__nfet_g5v0d10v5[id]
destroy all
alter vdd dc=3.3
alter rl 1000
alter cl 1e-11
ac dec 40 100 1G
wrdata ../build/d2s_ac_ss_T27_V3.3_r1k_cl10p.txt mag(v(pad)) ph(v(pad))
destroy all
alter cl 1e-10
ac dec 40 100 1G
wrdata ../build/d2s_ac_ss_T27_V3.3_r1k_cl100p.txt mag(v(pad)) ph(v(pad))
destroy all
alter cl 3e-10
ac dec 40 100 1G
wrdata ../build/d2s_ac_ss_T27_V3.3_r1k_cl300p.txt mag(v(pad)) ph(v(pad))
destroy all
alter rl 1e+09
alter cl 1e-11
ac dec 40 100 1G
wrdata ../build/d2s_ac_ss_T27_V3.3_open_cl10p.txt mag(v(pad)) ph(v(pad))
destroy all
alter cl 1e-10
ac dec 40 100 1G
wrdata ../build/d2s_ac_ss_T27_V3.3_open_cl100p.txt mag(v(pad)) ph(v(pad))
destroy all
alter cl 3e-10
ac dec 40 100 1G
wrdata ../build/d2s_ac_ss_T27_V3.3_open_cl300p.txt mag(v(pad)) ph(v(pad))
destroy all
alter rl 1k
op
wrdata ../build/d2s_op_ss_T27_V3.3.txt v(pad) i(vdd) @m.x1.xa.xop.msky130_fd_pr__pfet_g5v0d10v5[id] @m.x1.xa.xon.msky130_fd_pr__nfet_g5v0d10v5[id]
destroy all
alter vdd dc=3.6
alter rl 1000
alter cl 1e-11
ac dec 40 100 1G
wrdata ../build/d2s_ac_ss_T27_V3.6_r1k_cl10p.txt mag(v(pad)) ph(v(pad))
destroy all
alter cl 1e-10
ac dec 40 100 1G
wrdata ../build/d2s_ac_ss_T27_V3.6_r1k_cl100p.txt mag(v(pad)) ph(v(pad))
destroy all
alter cl 3e-10
ac dec 40 100 1G
wrdata ../build/d2s_ac_ss_T27_V3.6_r1k_cl300p.txt mag(v(pad)) ph(v(pad))
destroy all
alter rl 1e+09
alter cl 1e-11
ac dec 40 100 1G
wrdata ../build/d2s_ac_ss_T27_V3.6_open_cl10p.txt mag(v(pad)) ph(v(pad))
destroy all
alter cl 1e-10
ac dec 40 100 1G
wrdata ../build/d2s_ac_ss_T27_V3.6_open_cl100p.txt mag(v(pad)) ph(v(pad))
destroy all
alter cl 3e-10
ac dec 40 100 1G
wrdata ../build/d2s_ac_ss_T27_V3.6_open_cl300p.txt mag(v(pad)) ph(v(pad))
destroy all
alter rl 1k
op
wrdata ../build/d2s_op_ss_T27_V3.6.txt v(pad) i(vdd) @m.x1.xa.xop.msky130_fd_pr__pfet_g5v0d10v5[id] @m.x1.xa.xon.msky130_fd_pr__nfet_g5v0d10v5[id]
destroy all
option temp=125
alter vdd dc=3.0
alter rl 1000
alter cl 1e-11
ac dec 40 100 1G
wrdata ../build/d2s_ac_ss_T125_V3_r1k_cl10p.txt mag(v(pad)) ph(v(pad))
destroy all
alter cl 1e-10
ac dec 40 100 1G
wrdata ../build/d2s_ac_ss_T125_V3_r1k_cl100p.txt mag(v(pad)) ph(v(pad))
destroy all
alter cl 3e-10
ac dec 40 100 1G
wrdata ../build/d2s_ac_ss_T125_V3_r1k_cl300p.txt mag(v(pad)) ph(v(pad))
destroy all
alter rl 1e+09
alter cl 1e-11
ac dec 40 100 1G
wrdata ../build/d2s_ac_ss_T125_V3_open_cl10p.txt mag(v(pad)) ph(v(pad))
destroy all
alter cl 1e-10
ac dec 40 100 1G
wrdata ../build/d2s_ac_ss_T125_V3_open_cl100p.txt mag(v(pad)) ph(v(pad))
destroy all
alter cl 3e-10
ac dec 40 100 1G
wrdata ../build/d2s_ac_ss_T125_V3_open_cl300p.txt mag(v(pad)) ph(v(pad))
destroy all
alter rl 1k
op
wrdata ../build/d2s_op_ss_T125_V3.txt v(pad) i(vdd) @m.x1.xa.xop.msky130_fd_pr__pfet_g5v0d10v5[id] @m.x1.xa.xon.msky130_fd_pr__nfet_g5v0d10v5[id]
destroy all
alter vdd dc=3.3
alter rl 1000
alter cl 1e-11
ac dec 40 100 1G
wrdata ../build/d2s_ac_ss_T125_V3.3_r1k_cl10p.txt mag(v(pad)) ph(v(pad))
destroy all
alter cl 1e-10
ac dec 40 100 1G
wrdata ../build/d2s_ac_ss_T125_V3.3_r1k_cl100p.txt mag(v(pad)) ph(v(pad))
destroy all
alter cl 3e-10
ac dec 40 100 1G
wrdata ../build/d2s_ac_ss_T125_V3.3_r1k_cl300p.txt mag(v(pad)) ph(v(pad))
destroy all
alter rl 1e+09
alter cl 1e-11
ac dec 40 100 1G
wrdata ../build/d2s_ac_ss_T125_V3.3_open_cl10p.txt mag(v(pad)) ph(v(pad))
destroy all
alter cl 1e-10
ac dec 40 100 1G
wrdata ../build/d2s_ac_ss_T125_V3.3_open_cl100p.txt mag(v(pad)) ph(v(pad))
destroy all
alter cl 3e-10
ac dec 40 100 1G
wrdata ../build/d2s_ac_ss_T125_V3.3_open_cl300p.txt mag(v(pad)) ph(v(pad))
destroy all
alter rl 1k
op
wrdata ../build/d2s_op_ss_T125_V3.3.txt v(pad) i(vdd) @m.x1.xa.xop.msky130_fd_pr__pfet_g5v0d10v5[id] @m.x1.xa.xon.msky130_fd_pr__nfet_g5v0d10v5[id]
destroy all
alter vdd dc=3.6
alter rl 1000
alter cl 1e-11
ac dec 40 100 1G
wrdata ../build/d2s_ac_ss_T125_V3.6_r1k_cl10p.txt mag(v(pad)) ph(v(pad))
destroy all
alter cl 1e-10
ac dec 40 100 1G
wrdata ../build/d2s_ac_ss_T125_V3.6_r1k_cl100p.txt mag(v(pad)) ph(v(pad))
destroy all
alter cl 3e-10
ac dec 40 100 1G
wrdata ../build/d2s_ac_ss_T125_V3.6_r1k_cl300p.txt mag(v(pad)) ph(v(pad))
destroy all
alter rl 1e+09
alter cl 1e-11
ac dec 40 100 1G
wrdata ../build/d2s_ac_ss_T125_V3.6_open_cl10p.txt mag(v(pad)) ph(v(pad))
destroy all
alter cl 1e-10
ac dec 40 100 1G
wrdata ../build/d2s_ac_ss_T125_V3.6_open_cl100p.txt mag(v(pad)) ph(v(pad))
destroy all
alter cl 3e-10
ac dec 40 100 1G
wrdata ../build/d2s_ac_ss_T125_V3.6_open_cl300p.txt mag(v(pad)) ph(v(pad))
destroy all
alter rl 1k
op
wrdata ../build/d2s_op_ss_T125_V3.6.txt v(pad) i(vdd) @m.x1.xa.xop.msky130_fd_pr__pfet_g5v0d10v5[id] @m.x1.xa.xon.msky130_fd_pr__nfet_g5v0d10v5[id]
destroy all
.endc
.end
