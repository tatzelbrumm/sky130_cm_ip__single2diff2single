* s2d_ac_fs: S2D core closed-loop AC, corner fs
* SPDX-FileCopyrightText: 2026 Christoph Maier
* SPDX-License-Identifier: Apache-2.0
* sky130 pre-layout schematic simulation (feasibility, not sign-off).
* Generated by scripts/gen_decks.py; regenerate rather than edit. Run from decks/: ngspice -b <deck>
* pad = vref = 0.49 V (mid-scale u = 0), vcm = 1.05 V (sky130 port value),
* 0.5 pF external load per output plus the built-in 16 x 16 um MIM.
* Run 1: ac 1 on pad -> vd = v(op) - v(on) (ideal 2).  Run 2: ac 1 on vcm -> vc = (v(op) + v(on))/2 (ideal 1).
.lib /foss/pdks/sky130A/libs.tech/ngspice/sky130.lib.spice fs
.include ../netlists/units_sky130.spice
.include ../netlists/s2d_core_sky130.spice
Vdd vdd 0 3.3
Vref vref 0 0.49
Vcm vcm 0 dc 1.05 ac 0
Vin vin 0 dc 0.49 ac 1
Iref vdd iref 5u
X1 vdd 0 vin vref vcm op on iref s2d_core_sky130
CLp op 0 5e-13
CLn on 0 5e-13
.control
set wr_singlescale
set wr_vecnames
option numdgt=8
option temp=-40
alter vdd dc=3.0
alter @vin[acmag]=1
alter @vcm[acmag]=0
ac dec 40 100 1G
let vd = v(op) - v(on)
wrdata ../build/s2d_acd_fs_T-40_V3.txt mag(vd) ph(vd)
destroy all
alter @vin[acmag]=0
alter @vcm[acmag]=1
ac dec 40 100 1G
let vc = (v(op) + v(on))/2
wrdata ../build/s2d_acc_fs_T-40_V3.txt mag(vc) ph(vc)
destroy all
op
wrdata ../build/s2d_op_fs_T-40_V3.txt v(op) v(on) i(vdd)
destroy all
alter vdd dc=3.3
alter @vin[acmag]=1
alter @vcm[acmag]=0
ac dec 40 100 1G
let vd = v(op) - v(on)
wrdata ../build/s2d_acd_fs_T-40_V3.3.txt mag(vd) ph(vd)
destroy all
alter @vin[acmag]=0
alter @vcm[acmag]=1
ac dec 40 100 1G
let vc = (v(op) + v(on))/2
wrdata ../build/s2d_acc_fs_T-40_V3.3.txt mag(vc) ph(vc)
destroy all
op
wrdata ../build/s2d_op_fs_T-40_V3.3.txt v(op) v(on) i(vdd)
destroy all
alter vdd dc=3.6
alter @vin[acmag]=1
alter @vcm[acmag]=0
ac dec 40 100 1G
let vd = v(op) - v(on)
wrdata ../build/s2d_acd_fs_T-40_V3.6.txt mag(vd) ph(vd)
destroy all
alter @vin[acmag]=0
alter @vcm[acmag]=1
ac dec 40 100 1G
let vc = (v(op) + v(on))/2
wrdata ../build/s2d_acc_fs_T-40_V3.6.txt mag(vc) ph(vc)
destroy all
op
wrdata ../build/s2d_op_fs_T-40_V3.6.txt v(op) v(on) i(vdd)
destroy all
option temp=27
alter vdd dc=3.0
alter @vin[acmag]=1
alter @vcm[acmag]=0
ac dec 40 100 1G
let vd = v(op) - v(on)
wrdata ../build/s2d_acd_fs_T27_V3.txt mag(vd) ph(vd)
destroy all
alter @vin[acmag]=0
alter @vcm[acmag]=1
ac dec 40 100 1G
let vc = (v(op) + v(on))/2
wrdata ../build/s2d_acc_fs_T27_V3.txt mag(vc) ph(vc)
destroy all
op
wrdata ../build/s2d_op_fs_T27_V3.txt v(op) v(on) i(vdd)
destroy all
alter vdd dc=3.3
alter @vin[acmag]=1
alter @vcm[acmag]=0
ac dec 40 100 1G
let vd = v(op) - v(on)
wrdata ../build/s2d_acd_fs_T27_V3.3.txt mag(vd) ph(vd)
destroy all
alter @vin[acmag]=0
alter @vcm[acmag]=1
ac dec 40 100 1G
let vc = (v(op) + v(on))/2
wrdata ../build/s2d_acc_fs_T27_V3.3.txt mag(vc) ph(vc)
destroy all
op
wrdata ../build/s2d_op_fs_T27_V3.3.txt v(op) v(on) i(vdd)
destroy all
alter vdd dc=3.6
alter @vin[acmag]=1
alter @vcm[acmag]=0
ac dec 40 100 1G
let vd = v(op) - v(on)
wrdata ../build/s2d_acd_fs_T27_V3.6.txt mag(vd) ph(vd)
destroy all
alter @vin[acmag]=0
alter @vcm[acmag]=1
ac dec 40 100 1G
let vc = (v(op) + v(on))/2
wrdata ../build/s2d_acc_fs_T27_V3.6.txt mag(vc) ph(vc)
destroy all
op
wrdata ../build/s2d_op_fs_T27_V3.6.txt v(op) v(on) i(vdd)
destroy all
option temp=125
alter vdd dc=3.0
alter @vin[acmag]=1
alter @vcm[acmag]=0
ac dec 40 100 1G
let vd = v(op) - v(on)
wrdata ../build/s2d_acd_fs_T125_V3.txt mag(vd) ph(vd)
destroy all
alter @vin[acmag]=0
alter @vcm[acmag]=1
ac dec 40 100 1G
let vc = (v(op) + v(on))/2
wrdata ../build/s2d_acc_fs_T125_V3.txt mag(vc) ph(vc)
destroy all
op
wrdata ../build/s2d_op_fs_T125_V3.txt v(op) v(on) i(vdd)
destroy all
alter vdd dc=3.3
alter @vin[acmag]=1
alter @vcm[acmag]=0
ac dec 40 100 1G
let vd = v(op) - v(on)
wrdata ../build/s2d_acd_fs_T125_V3.3.txt mag(vd) ph(vd)
destroy all
alter @vin[acmag]=0
alter @vcm[acmag]=1
ac dec 40 100 1G
let vc = (v(op) + v(on))/2
wrdata ../build/s2d_acc_fs_T125_V3.3.txt mag(vc) ph(vc)
destroy all
op
wrdata ../build/s2d_op_fs_T125_V3.3.txt v(op) v(on) i(vdd)
destroy all
alter vdd dc=3.6
alter @vin[acmag]=1
alter @vcm[acmag]=0
ac dec 40 100 1G
let vd = v(op) - v(on)
wrdata ../build/s2d_acd_fs_T125_V3.6.txt mag(vd) ph(vd)
destroy all
alter @vin[acmag]=0
alter @vcm[acmag]=1
ac dec 40 100 1G
let vc = (v(op) + v(on))/2
wrdata ../build/s2d_acc_fs_T125_V3.6.txt mag(vc) ph(vc)
destroy all
op
wrdata ../build/s2d_op_fs_T125_V3.6.txt v(op) v(on) i(vdd)
destroy all
.endc
.end
