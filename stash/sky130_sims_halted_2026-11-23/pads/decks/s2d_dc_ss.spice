* s2d_dc_ss: S2D core DC transfer, corner ss
* SPDX-FileCopyrightText: 2026 Christoph Maier
* SPDX-License-Identifier: Apache-2.0
* sky130 pre-layout schematic simulation (feasibility, not sign-off).
* Generated by scripts/gen_decks.py; regenerate rather than edit. Run from decks/: ngspice -b <deck>
* Pad (vin) swept 0 .. 1 V in 10 mV steps; vref = 0.49 V; vcm swept for the input/output window.
* Ideal 5 uA iref sourced into the bias tree; 0.5 pF external load per output (DC: no effect).
.lib /foss/pdks/sky130A/libs.tech/ngspice/sky130.lib.spice ss
.include ../netlists/units_sky130.spice
.include ../netlists/s2d_core_sky130.spice
Vdd vdd 0 3.3
Vref vref 0 0.49
Vcm vcm 0 1.26
Vin vin 0 0.49
Iref vdd iref 5u
X1 vdd 0 vin vref vcm op on iref s2d_core_sky130
CLp op 0 5e-13
CLn on 0 5e-13
.control
set wr_singlescale
set wr_vecnames
option numdgt=8
option temp=-40
alter vdd dc=3.0
alter vcm dc=0.8
dc vin 0 1 0.01
wrdata ../build/s2d_dc_ss_T-40_V3_cm0.8.txt v(op) v(on) i(vdd)
destroy all
alter vcm dc=0.85
dc vin 0 1 0.01
wrdata ../build/s2d_dc_ss_T-40_V3_cm0.85.txt v(op) v(on) i(vdd)
destroy all
alter vcm dc=0.9
dc vin 0 1 0.01
wrdata ../build/s2d_dc_ss_T-40_V3_cm0.9.txt v(op) v(on) i(vdd)
destroy all
alter vcm dc=0.95
dc vin 0 1 0.01
wrdata ../build/s2d_dc_ss_T-40_V3_cm0.95.txt v(op) v(on) i(vdd)
destroy all
alter vcm dc=1.0
dc vin 0 1 0.01
wrdata ../build/s2d_dc_ss_T-40_V3_cm1.txt v(op) v(on) i(vdd)
destroy all
alter vcm dc=1.05
dc vin 0 1 0.01
wrdata ../build/s2d_dc_ss_T-40_V3_cm1.05.txt v(op) v(on) i(vdd)
destroy all
alter vcm dc=1.1
dc vin 0 1 0.01
wrdata ../build/s2d_dc_ss_T-40_V3_cm1.1.txt v(op) v(on) i(vdd)
destroy all
alter vcm dc=1.15
dc vin 0 1 0.01
wrdata ../build/s2d_dc_ss_T-40_V3_cm1.15.txt v(op) v(on) i(vdd)
destroy all
alter vcm dc=1.2
dc vin 0 1 0.01
wrdata ../build/s2d_dc_ss_T-40_V3_cm1.2.txt v(op) v(on) i(vdd)
destroy all
alter vcm dc=1.25
dc vin 0 1 0.01
wrdata ../build/s2d_dc_ss_T-40_V3_cm1.25.txt v(op) v(on) i(vdd)
destroy all
alter vcm dc=1.3
dc vin 0 1 0.01
wrdata ../build/s2d_dc_ss_T-40_V3_cm1.3.txt v(op) v(on) i(vdd)
destroy all
alter vcm dc=1.35
dc vin 0 1 0.01
wrdata ../build/s2d_dc_ss_T-40_V3_cm1.35.txt v(op) v(on) i(vdd)
destroy all
alter vcm dc=1.4
dc vin 0 1 0.01
wrdata ../build/s2d_dc_ss_T-40_V3_cm1.4.txt v(op) v(on) i(vdd)
destroy all
alter vcm dc=1.26
dc vin 0 1 0.01
wrdata ../build/s2d_dc_ss_T-40_V3_cm1.26.txt v(op) v(on) i(vdd)
destroy all
alter vdd dc=3.3
alter vcm dc=0.8
dc vin 0 1 0.01
wrdata ../build/s2d_dc_ss_T-40_V3.3_cm0.8.txt v(op) v(on) i(vdd)
destroy all
alter vcm dc=0.85
dc vin 0 1 0.01
wrdata ../build/s2d_dc_ss_T-40_V3.3_cm0.85.txt v(op) v(on) i(vdd)
destroy all
alter vcm dc=0.9
dc vin 0 1 0.01
wrdata ../build/s2d_dc_ss_T-40_V3.3_cm0.9.txt v(op) v(on) i(vdd)
destroy all
alter vcm dc=0.95
dc vin 0 1 0.01
wrdata ../build/s2d_dc_ss_T-40_V3.3_cm0.95.txt v(op) v(on) i(vdd)
destroy all
alter vcm dc=1.0
dc vin 0 1 0.01
wrdata ../build/s2d_dc_ss_T-40_V3.3_cm1.txt v(op) v(on) i(vdd)
destroy all
alter vcm dc=1.05
dc vin 0 1 0.01
wrdata ../build/s2d_dc_ss_T-40_V3.3_cm1.05.txt v(op) v(on) i(vdd)
destroy all
alter vcm dc=1.1
dc vin 0 1 0.01
wrdata ../build/s2d_dc_ss_T-40_V3.3_cm1.1.txt v(op) v(on) i(vdd)
destroy all
alter vcm dc=1.15
dc vin 0 1 0.01
wrdata ../build/s2d_dc_ss_T-40_V3.3_cm1.15.txt v(op) v(on) i(vdd)
destroy all
alter vcm dc=1.2
dc vin 0 1 0.01
wrdata ../build/s2d_dc_ss_T-40_V3.3_cm1.2.txt v(op) v(on) i(vdd)
destroy all
alter vcm dc=1.25
dc vin 0 1 0.01
wrdata ../build/s2d_dc_ss_T-40_V3.3_cm1.25.txt v(op) v(on) i(vdd)
destroy all
alter vcm dc=1.3
dc vin 0 1 0.01
wrdata ../build/s2d_dc_ss_T-40_V3.3_cm1.3.txt v(op) v(on) i(vdd)
destroy all
alter vcm dc=1.35
dc vin 0 1 0.01
wrdata ../build/s2d_dc_ss_T-40_V3.3_cm1.35.txt v(op) v(on) i(vdd)
destroy all
alter vcm dc=1.4
dc vin 0 1 0.01
wrdata ../build/s2d_dc_ss_T-40_V3.3_cm1.4.txt v(op) v(on) i(vdd)
destroy all
alter vcm dc=1.26
dc vin 0 1 0.01
wrdata ../build/s2d_dc_ss_T-40_V3.3_cm1.26.txt v(op) v(on) i(vdd)
destroy all
alter vdd dc=3.6
alter vcm dc=0.8
dc vin 0 1 0.01
wrdata ../build/s2d_dc_ss_T-40_V3.6_cm0.8.txt v(op) v(on) i(vdd)
destroy all
alter vcm dc=0.85
dc vin 0 1 0.01
wrdata ../build/s2d_dc_ss_T-40_V3.6_cm0.85.txt v(op) v(on) i(vdd)
destroy all
alter vcm dc=0.9
dc vin 0 1 0.01
wrdata ../build/s2d_dc_ss_T-40_V3.6_cm0.9.txt v(op) v(on) i(vdd)
destroy all
alter vcm dc=0.95
dc vin 0 1 0.01
wrdata ../build/s2d_dc_ss_T-40_V3.6_cm0.95.txt v(op) v(on) i(vdd)
destroy all
alter vcm dc=1.0
dc vin 0 1 0.01
wrdata ../build/s2d_dc_ss_T-40_V3.6_cm1.txt v(op) v(on) i(vdd)
destroy all
alter vcm dc=1.05
dc vin 0 1 0.01
wrdata ../build/s2d_dc_ss_T-40_V3.6_cm1.05.txt v(op) v(on) i(vdd)
destroy all
alter vcm dc=1.1
dc vin 0 1 0.01
wrdata ../build/s2d_dc_ss_T-40_V3.6_cm1.1.txt v(op) v(on) i(vdd)
destroy all
alter vcm dc=1.15
dc vin 0 1 0.01
wrdata ../build/s2d_dc_ss_T-40_V3.6_cm1.15.txt v(op) v(on) i(vdd)
destroy all
alter vcm dc=1.2
dc vin 0 1 0.01
wrdata ../build/s2d_dc_ss_T-40_V3.6_cm1.2.txt v(op) v(on) i(vdd)
destroy all
alter vcm dc=1.25
dc vin 0 1 0.01
wrdata ../build/s2d_dc_ss_T-40_V3.6_cm1.25.txt v(op) v(on) i(vdd)
destroy all
alter vcm dc=1.3
dc vin 0 1 0.01
wrdata ../build/s2d_dc_ss_T-40_V3.6_cm1.3.txt v(op) v(on) i(vdd)
destroy all
alter vcm dc=1.35
dc vin 0 1 0.01
wrdata ../build/s2d_dc_ss_T-40_V3.6_cm1.35.txt v(op) v(on) i(vdd)
destroy all
alter vcm dc=1.4
dc vin 0 1 0.01
wrdata ../build/s2d_dc_ss_T-40_V3.6_cm1.4.txt v(op) v(on) i(vdd)
destroy all
alter vcm dc=1.26
dc vin 0 1 0.01
wrdata ../build/s2d_dc_ss_T-40_V3.6_cm1.26.txt v(op) v(on) i(vdd)
destroy all
option temp=27
alter vdd dc=3.0
alter vcm dc=0.8
dc vin 0 1 0.01
wrdata ../build/s2d_dc_ss_T27_V3_cm0.8.txt v(op) v(on) i(vdd)
destroy all
alter vcm dc=0.85
dc vin 0 1 0.01
wrdata ../build/s2d_dc_ss_T27_V3_cm0.85.txt v(op) v(on) i(vdd)
destroy all
alter vcm dc=0.9
dc vin 0 1 0.01
wrdata ../build/s2d_dc_ss_T27_V3_cm0.9.txt v(op) v(on) i(vdd)
destroy all
alter vcm dc=0.95
dc vin 0 1 0.01
wrdata ../build/s2d_dc_ss_T27_V3_cm0.95.txt v(op) v(on) i(vdd)
destroy all
alter vcm dc=1.0
dc vin 0 1 0.01
wrdata ../build/s2d_dc_ss_T27_V3_cm1.txt v(op) v(on) i(vdd)
destroy all
alter vcm dc=1.05
dc vin 0 1 0.01
wrdata ../build/s2d_dc_ss_T27_V3_cm1.05.txt v(op) v(on) i(vdd)
destroy all
alter vcm dc=1.1
dc vin 0 1 0.01
wrdata ../build/s2d_dc_ss_T27_V3_cm1.1.txt v(op) v(on) i(vdd)
destroy all
alter vcm dc=1.15
dc vin 0 1 0.01
wrdata ../build/s2d_dc_ss_T27_V3_cm1.15.txt v(op) v(on) i(vdd)
destroy all
alter vcm dc=1.2
dc vin 0 1 0.01
wrdata ../build/s2d_dc_ss_T27_V3_cm1.2.txt v(op) v(on) i(vdd)
destroy all
alter vcm dc=1.25
dc vin 0 1 0.01
wrdata ../build/s2d_dc_ss_T27_V3_cm1.25.txt v(op) v(on) i(vdd)
destroy all
alter vcm dc=1.3
dc vin 0 1 0.01
wrdata ../build/s2d_dc_ss_T27_V3_cm1.3.txt v(op) v(on) i(vdd)
destroy all
alter vcm dc=1.35
dc vin 0 1 0.01
wrdata ../build/s2d_dc_ss_T27_V3_cm1.35.txt v(op) v(on) i(vdd)
destroy all
alter vcm dc=1.4
dc vin 0 1 0.01
wrdata ../build/s2d_dc_ss_T27_V3_cm1.4.txt v(op) v(on) i(vdd)
destroy all
alter vcm dc=1.26
dc vin 0 1 0.01
wrdata ../build/s2d_dc_ss_T27_V3_cm1.26.txt v(op) v(on) i(vdd)
destroy all
alter vdd dc=3.3
alter vcm dc=0.8
dc vin 0 1 0.01
wrdata ../build/s2d_dc_ss_T27_V3.3_cm0.8.txt v(op) v(on) i(vdd)
destroy all
alter vcm dc=0.85
dc vin 0 1 0.01
wrdata ../build/s2d_dc_ss_T27_V3.3_cm0.85.txt v(op) v(on) i(vdd)
destroy all
alter vcm dc=0.9
dc vin 0 1 0.01
wrdata ../build/s2d_dc_ss_T27_V3.3_cm0.9.txt v(op) v(on) i(vdd)
destroy all
alter vcm dc=0.95
dc vin 0 1 0.01
wrdata ../build/s2d_dc_ss_T27_V3.3_cm0.95.txt v(op) v(on) i(vdd)
destroy all
alter vcm dc=1.0
dc vin 0 1 0.01
wrdata ../build/s2d_dc_ss_T27_V3.3_cm1.txt v(op) v(on) i(vdd)
destroy all
alter vcm dc=1.05
dc vin 0 1 0.01
wrdata ../build/s2d_dc_ss_T27_V3.3_cm1.05.txt v(op) v(on) i(vdd)
destroy all
alter vcm dc=1.1
dc vin 0 1 0.01
wrdata ../build/s2d_dc_ss_T27_V3.3_cm1.1.txt v(op) v(on) i(vdd)
destroy all
alter vcm dc=1.15
dc vin 0 1 0.01
wrdata ../build/s2d_dc_ss_T27_V3.3_cm1.15.txt v(op) v(on) i(vdd)
destroy all
alter vcm dc=1.2
dc vin 0 1 0.01
wrdata ../build/s2d_dc_ss_T27_V3.3_cm1.2.txt v(op) v(on) i(vdd)
destroy all
alter vcm dc=1.25
dc vin 0 1 0.01
wrdata ../build/s2d_dc_ss_T27_V3.3_cm1.25.txt v(op) v(on) i(vdd)
destroy all
alter vcm dc=1.3
dc vin 0 1 0.01
wrdata ../build/s2d_dc_ss_T27_V3.3_cm1.3.txt v(op) v(on) i(vdd)
destroy all
alter vcm dc=1.35
dc vin 0 1 0.01
wrdata ../build/s2d_dc_ss_T27_V3.3_cm1.35.txt v(op) v(on) i(vdd)
destroy all
alter vcm dc=1.4
dc vin 0 1 0.01
wrdata ../build/s2d_dc_ss_T27_V3.3_cm1.4.txt v(op) v(on) i(vdd)
destroy all
alter vcm dc=1.26
dc vin 0 1 0.01
wrdata ../build/s2d_dc_ss_T27_V3.3_cm1.26.txt v(op) v(on) i(vdd)
destroy all
alter vdd dc=3.6
alter vcm dc=0.8
dc vin 0 1 0.01
wrdata ../build/s2d_dc_ss_T27_V3.6_cm0.8.txt v(op) v(on) i(vdd)
destroy all
alter vcm dc=0.85
dc vin 0 1 0.01
wrdata ../build/s2d_dc_ss_T27_V3.6_cm0.85.txt v(op) v(on) i(vdd)
destroy all
alter vcm dc=0.9
dc vin 0 1 0.01
wrdata ../build/s2d_dc_ss_T27_V3.6_cm0.9.txt v(op) v(on) i(vdd)
destroy all
alter vcm dc=0.95
dc vin 0 1 0.01
wrdata ../build/s2d_dc_ss_T27_V3.6_cm0.95.txt v(op) v(on) i(vdd)
destroy all
alter vcm dc=1.0
dc vin 0 1 0.01
wrdata ../build/s2d_dc_ss_T27_V3.6_cm1.txt v(op) v(on) i(vdd)
destroy all
alter vcm dc=1.05
dc vin 0 1 0.01
wrdata ../build/s2d_dc_ss_T27_V3.6_cm1.05.txt v(op) v(on) i(vdd)
destroy all
alter vcm dc=1.1
dc vin 0 1 0.01
wrdata ../build/s2d_dc_ss_T27_V3.6_cm1.1.txt v(op) v(on) i(vdd)
destroy all
alter vcm dc=1.15
dc vin 0 1 0.01
wrdata ../build/s2d_dc_ss_T27_V3.6_cm1.15.txt v(op) v(on) i(vdd)
destroy all
alter vcm dc=1.2
dc vin 0 1 0.01
wrdata ../build/s2d_dc_ss_T27_V3.6_cm1.2.txt v(op) v(on) i(vdd)
destroy all
alter vcm dc=1.25
dc vin 0 1 0.01
wrdata ../build/s2d_dc_ss_T27_V3.6_cm1.25.txt v(op) v(on) i(vdd)
destroy all
alter vcm dc=1.3
dc vin 0 1 0.01
wrdata ../build/s2d_dc_ss_T27_V3.6_cm1.3.txt v(op) v(on) i(vdd)
destroy all
alter vcm dc=1.35
dc vin 0 1 0.01
wrdata ../build/s2d_dc_ss_T27_V3.6_cm1.35.txt v(op) v(on) i(vdd)
destroy all
alter vcm dc=1.4
dc vin 0 1 0.01
wrdata ../build/s2d_dc_ss_T27_V3.6_cm1.4.txt v(op) v(on) i(vdd)
destroy all
alter vcm dc=1.26
dc vin 0 1 0.01
wrdata ../build/s2d_dc_ss_T27_V3.6_cm1.26.txt v(op) v(on) i(vdd)
destroy all
option temp=125
alter vdd dc=3.0
alter vcm dc=0.8
dc vin 0 1 0.01
wrdata ../build/s2d_dc_ss_T125_V3_cm0.8.txt v(op) v(on) i(vdd)
destroy all
alter vcm dc=0.85
dc vin 0 1 0.01
wrdata ../build/s2d_dc_ss_T125_V3_cm0.85.txt v(op) v(on) i(vdd)
destroy all
alter vcm dc=0.9
dc vin 0 1 0.01
wrdata ../build/s2d_dc_ss_T125_V3_cm0.9.txt v(op) v(on) i(vdd)
destroy all
alter vcm dc=0.95
dc vin 0 1 0.01
wrdata ../build/s2d_dc_ss_T125_V3_cm0.95.txt v(op) v(on) i(vdd)
destroy all
alter vcm dc=1.0
dc vin 0 1 0.01
wrdata ../build/s2d_dc_ss_T125_V3_cm1.txt v(op) v(on) i(vdd)
destroy all
alter vcm dc=1.05
dc vin 0 1 0.01
wrdata ../build/s2d_dc_ss_T125_V3_cm1.05.txt v(op) v(on) i(vdd)
destroy all
alter vcm dc=1.1
dc vin 0 1 0.01
wrdata ../build/s2d_dc_ss_T125_V3_cm1.1.txt v(op) v(on) i(vdd)
destroy all
alter vcm dc=1.15
dc vin 0 1 0.01
wrdata ../build/s2d_dc_ss_T125_V3_cm1.15.txt v(op) v(on) i(vdd)
destroy all
alter vcm dc=1.2
dc vin 0 1 0.01
wrdata ../build/s2d_dc_ss_T125_V3_cm1.2.txt v(op) v(on) i(vdd)
destroy all
alter vcm dc=1.25
dc vin 0 1 0.01
wrdata ../build/s2d_dc_ss_T125_V3_cm1.25.txt v(op) v(on) i(vdd)
destroy all
alter vcm dc=1.3
dc vin 0 1 0.01
wrdata ../build/s2d_dc_ss_T125_V3_cm1.3.txt v(op) v(on) i(vdd)
destroy all
alter vcm dc=1.35
dc vin 0 1 0.01
wrdata ../build/s2d_dc_ss_T125_V3_cm1.35.txt v(op) v(on) i(vdd)
destroy all
alter vcm dc=1.4
dc vin 0 1 0.01
wrdata ../build/s2d_dc_ss_T125_V3_cm1.4.txt v(op) v(on) i(vdd)
destroy all
alter vcm dc=1.26
dc vin 0 1 0.01
wrdata ../build/s2d_dc_ss_T125_V3_cm1.26.txt v(op) v(on) i(vdd)
destroy all
alter vdd dc=3.3
alter vcm dc=0.8
dc vin 0 1 0.01
wrdata ../build/s2d_dc_ss_T125_V3.3_cm0.8.txt v(op) v(on) i(vdd)
destroy all
alter vcm dc=0.85
dc vin 0 1 0.01
wrdata ../build/s2d_dc_ss_T125_V3.3_cm0.85.txt v(op) v(on) i(vdd)
destroy all
alter vcm dc=0.9
dc vin 0 1 0.01
wrdata ../build/s2d_dc_ss_T125_V3.3_cm0.9.txt v(op) v(on) i(vdd)
destroy all
alter vcm dc=0.95
dc vin 0 1 0.01
wrdata ../build/s2d_dc_ss_T125_V3.3_cm0.95.txt v(op) v(on) i(vdd)
destroy all
alter vcm dc=1.0
dc vin 0 1 0.01
wrdata ../build/s2d_dc_ss_T125_V3.3_cm1.txt v(op) v(on) i(vdd)
destroy all
alter vcm dc=1.05
dc vin 0 1 0.01
wrdata ../build/s2d_dc_ss_T125_V3.3_cm1.05.txt v(op) v(on) i(vdd)
destroy all
alter vcm dc=1.1
dc vin 0 1 0.01
wrdata ../build/s2d_dc_ss_T125_V3.3_cm1.1.txt v(op) v(on) i(vdd)
destroy all
alter vcm dc=1.15
dc vin 0 1 0.01
wrdata ../build/s2d_dc_ss_T125_V3.3_cm1.15.txt v(op) v(on) i(vdd)
destroy all
alter vcm dc=1.2
dc vin 0 1 0.01
wrdata ../build/s2d_dc_ss_T125_V3.3_cm1.2.txt v(op) v(on) i(vdd)
destroy all
alter vcm dc=1.25
dc vin 0 1 0.01
wrdata ../build/s2d_dc_ss_T125_V3.3_cm1.25.txt v(op) v(on) i(vdd)
destroy all
alter vcm dc=1.3
dc vin 0 1 0.01
wrdata ../build/s2d_dc_ss_T125_V3.3_cm1.3.txt v(op) v(on) i(vdd)
destroy all
alter vcm dc=1.35
dc vin 0 1 0.01
wrdata ../build/s2d_dc_ss_T125_V3.3_cm1.35.txt v(op) v(on) i(vdd)
destroy all
alter vcm dc=1.4
dc vin 0 1 0.01
wrdata ../build/s2d_dc_ss_T125_V3.3_cm1.4.txt v(op) v(on) i(vdd)
destroy all
alter vcm dc=1.26
dc vin 0 1 0.01
wrdata ../build/s2d_dc_ss_T125_V3.3_cm1.26.txt v(op) v(on) i(vdd)
destroy all
alter vdd dc=3.6
alter vcm dc=0.8
dc vin 0 1 0.01
wrdata ../build/s2d_dc_ss_T125_V3.6_cm0.8.txt v(op) v(on) i(vdd)
destroy all
alter vcm dc=0.85
dc vin 0 1 0.01
wrdata ../build/s2d_dc_ss_T125_V3.6_cm0.85.txt v(op) v(on) i(vdd)
destroy all
alter vcm dc=0.9
dc vin 0 1 0.01
wrdata ../build/s2d_dc_ss_T125_V3.6_cm0.9.txt v(op) v(on) i(vdd)
destroy all
alter vcm dc=0.95
dc vin 0 1 0.01
wrdata ../build/s2d_dc_ss_T125_V3.6_cm0.95.txt v(op) v(on) i(vdd)
destroy all
alter vcm dc=1.0
dc vin 0 1 0.01
wrdata ../build/s2d_dc_ss_T125_V3.6_cm1.txt v(op) v(on) i(vdd)
destroy all
alter vcm dc=1.05
dc vin 0 1 0.01
wrdata ../build/s2d_dc_ss_T125_V3.6_cm1.05.txt v(op) v(on) i(vdd)
destroy all
alter vcm dc=1.1
dc vin 0 1 0.01
wrdata ../build/s2d_dc_ss_T125_V3.6_cm1.1.txt v(op) v(on) i(vdd)
destroy all
alter vcm dc=1.15
dc vin 0 1 0.01
wrdata ../build/s2d_dc_ss_T125_V3.6_cm1.15.txt v(op) v(on) i(vdd)
destroy all
alter vcm dc=1.2
dc vin 0 1 0.01
wrdata ../build/s2d_dc_ss_T125_V3.6_cm1.2.txt v(op) v(on) i(vdd)
destroy all
alter vcm dc=1.25
dc vin 0 1 0.01
wrdata ../build/s2d_dc_ss_T125_V3.6_cm1.25.txt v(op) v(on) i(vdd)
destroy all
alter vcm dc=1.3
dc vin 0 1 0.01
wrdata ../build/s2d_dc_ss_T125_V3.6_cm1.3.txt v(op) v(on) i(vdd)
destroy all
alter vcm dc=1.35
dc vin 0 1 0.01
wrdata ../build/s2d_dc_ss_T125_V3.6_cm1.35.txt v(op) v(on) i(vdd)
destroy all
alter vcm dc=1.4
dc vin 0 1 0.01
wrdata ../build/s2d_dc_ss_T125_V3.6_cm1.4.txt v(op) v(on) i(vdd)
destroy all
alter vcm dc=1.26
dc vin 0 1 0.01
wrdata ../build/s2d_dc_ss_T125_V3.6_cm1.26.txt v(op) v(on) i(vdd)
destroy all
.endc
.end
