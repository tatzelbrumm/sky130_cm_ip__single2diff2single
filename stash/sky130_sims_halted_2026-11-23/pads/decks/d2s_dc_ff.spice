* d2s_dc_ff: D2S core DC transfer, corner ff
* SPDX-FileCopyrightText: 2026 Christoph Maier
* SPDX-License-Identifier: Apache-2.0
* sky130 pre-layout schematic simulation (feasibility, not sign-off).
* Generated by scripts/gen_decks.py; regenerate rather than edit. Run from decks/: ngspice -b <deck>
* vd = vinp - vinn swept -2 .. +2 V in 20 mV steps (INL over +-1 V, swing over +-2 V), input CM = vref;
* ideal pad - vref = vd/2.
* Load: Rl (1 kOhm or 1 GOhm = unloaded) from pad to vref (load termination at the reference).
* vref swept for the window; ideal 5 uA iref.
.lib /foss/pdks/sky130A/libs.tech/ngspice/sky130.lib.spice ff
.include ../netlists/units_sky130.spice
.include ../netlists/d2s_core_sky130.spice
Vdd vdd 0 3.3
Vref vref 0 1.26
Vd vd 0 0
* vinp = vref + vd/2, vinn = vref - vd/2 (input CM = vref = vcm line)
Ep vinp vref vd 0 0.5
En vinn vref vd 0 -0.5
Iref vdd iref 5u
X1 vdd 0 vinp vinn vref pad iref d2s_core_sky130
Rl pad vref 1k
Cl pad 0 100p
.control
set wr_singlescale
set wr_vecnames
option numdgt=8
option temp=-40
alter vdd dc=3.0
alter vref dc=0.9
alter rl 1000
dc vd -2 2 0.02
wrdata ../build/d2s_dc_ff_T-40_V3_vr0.9_r1k.txt v(pad) v(vref) i(vdd) @m.x1.xa.xop.msky130_fd_pr__pfet_g5v0d10v5[id] @m.x1.xa.xon.msky130_fd_pr__nfet_g5v0d10v5[id]
destroy all
alter rl 1e+09
dc vd -2 2 0.02
wrdata ../build/d2s_dc_ff_T-40_V3_vr0.9_open.txt v(pad) v(vref) i(vdd) @m.x1.xa.xop.msky130_fd_pr__pfet_g5v0d10v5[id] @m.x1.xa.xon.msky130_fd_pr__nfet_g5v0d10v5[id]
destroy all
alter vref dc=1.0
alter rl 1000
dc vd -2 2 0.02
wrdata ../build/d2s_dc_ff_T-40_V3_vr1_r1k.txt v(pad) v(vref) i(vdd) @m.x1.xa.xop.msky130_fd_pr__pfet_g5v0d10v5[id] @m.x1.xa.xon.msky130_fd_pr__nfet_g5v0d10v5[id]
destroy all
alter rl 1e+09
dc vd -2 2 0.02
wrdata ../build/d2s_dc_ff_T-40_V3_vr1_open.txt v(pad) v(vref) i(vdd) @m.x1.xa.xop.msky130_fd_pr__pfet_g5v0d10v5[id] @m.x1.xa.xon.msky130_fd_pr__nfet_g5v0d10v5[id]
destroy all
alter vref dc=1.1
alter rl 1000
dc vd -2 2 0.02
wrdata ../build/d2s_dc_ff_T-40_V3_vr1.1_r1k.txt v(pad) v(vref) i(vdd) @m.x1.xa.xop.msky130_fd_pr__pfet_g5v0d10v5[id] @m.x1.xa.xon.msky130_fd_pr__nfet_g5v0d10v5[id]
destroy all
alter rl 1e+09
dc vd -2 2 0.02
wrdata ../build/d2s_dc_ff_T-40_V3_vr1.1_open.txt v(pad) v(vref) i(vdd) @m.x1.xa.xop.msky130_fd_pr__pfet_g5v0d10v5[id] @m.x1.xa.xon.msky130_fd_pr__nfet_g5v0d10v5[id]
destroy all
alter vref dc=1.2
alter rl 1000
dc vd -2 2 0.02
wrdata ../build/d2s_dc_ff_T-40_V3_vr1.2_r1k.txt v(pad) v(vref) i(vdd) @m.x1.xa.xop.msky130_fd_pr__pfet_g5v0d10v5[id] @m.x1.xa.xon.msky130_fd_pr__nfet_g5v0d10v5[id]
destroy all
alter rl 1e+09
dc vd -2 2 0.02
wrdata ../build/d2s_dc_ff_T-40_V3_vr1.2_open.txt v(pad) v(vref) i(vdd) @m.x1.xa.xop.msky130_fd_pr__pfet_g5v0d10v5[id] @m.x1.xa.xon.msky130_fd_pr__nfet_g5v0d10v5[id]
destroy all
alter vref dc=1.3
alter rl 1000
dc vd -2 2 0.02
wrdata ../build/d2s_dc_ff_T-40_V3_vr1.3_r1k.txt v(pad) v(vref) i(vdd) @m.x1.xa.xop.msky130_fd_pr__pfet_g5v0d10v5[id] @m.x1.xa.xon.msky130_fd_pr__nfet_g5v0d10v5[id]
destroy all
alter rl 1e+09
dc vd -2 2 0.02
wrdata ../build/d2s_dc_ff_T-40_V3_vr1.3_open.txt v(pad) v(vref) i(vdd) @m.x1.xa.xop.msky130_fd_pr__pfet_g5v0d10v5[id] @m.x1.xa.xon.msky130_fd_pr__nfet_g5v0d10v5[id]
destroy all
alter vref dc=1.4
alter rl 1000
dc vd -2 2 0.02
wrdata ../build/d2s_dc_ff_T-40_V3_vr1.4_r1k.txt v(pad) v(vref) i(vdd) @m.x1.xa.xop.msky130_fd_pr__pfet_g5v0d10v5[id] @m.x1.xa.xon.msky130_fd_pr__nfet_g5v0d10v5[id]
destroy all
alter rl 1e+09
dc vd -2 2 0.02
wrdata ../build/d2s_dc_ff_T-40_V3_vr1.4_open.txt v(pad) v(vref) i(vdd) @m.x1.xa.xop.msky130_fd_pr__pfet_g5v0d10v5[id] @m.x1.xa.xon.msky130_fd_pr__nfet_g5v0d10v5[id]
destroy all
alter vref dc=1.5
alter rl 1000
dc vd -2 2 0.02
wrdata ../build/d2s_dc_ff_T-40_V3_vr1.5_r1k.txt v(pad) v(vref) i(vdd) @m.x1.xa.xop.msky130_fd_pr__pfet_g5v0d10v5[id] @m.x1.xa.xon.msky130_fd_pr__nfet_g5v0d10v5[id]
destroy all
alter rl 1e+09
dc vd -2 2 0.02
wrdata ../build/d2s_dc_ff_T-40_V3_vr1.5_open.txt v(pad) v(vref) i(vdd) @m.x1.xa.xop.msky130_fd_pr__pfet_g5v0d10v5[id] @m.x1.xa.xon.msky130_fd_pr__nfet_g5v0d10v5[id]
destroy all
alter vref dc=1.26
alter rl 1000
dc vd -2 2 0.02
wrdata ../build/d2s_dc_ff_T-40_V3_vr1.26_r1k.txt v(pad) v(vref) i(vdd) @m.x1.xa.xop.msky130_fd_pr__pfet_g5v0d10v5[id] @m.x1.xa.xon.msky130_fd_pr__nfet_g5v0d10v5[id]
destroy all
alter rl 1e+09
dc vd -2 2 0.02
wrdata ../build/d2s_dc_ff_T-40_V3_vr1.26_open.txt v(pad) v(vref) i(vdd) @m.x1.xa.xop.msky130_fd_pr__pfet_g5v0d10v5[id] @m.x1.xa.xon.msky130_fd_pr__nfet_g5v0d10v5[id]
destroy all
alter vdd dc=3.3
alter vref dc=0.9
alter rl 1000
dc vd -2 2 0.02
wrdata ../build/d2s_dc_ff_T-40_V3.3_vr0.9_r1k.txt v(pad) v(vref) i(vdd) @m.x1.xa.xop.msky130_fd_pr__pfet_g5v0d10v5[id] @m.x1.xa.xon.msky130_fd_pr__nfet_g5v0d10v5[id]
destroy all
alter rl 1e+09
dc vd -2 2 0.02
wrdata ../build/d2s_dc_ff_T-40_V3.3_vr0.9_open.txt v(pad) v(vref) i(vdd) @m.x1.xa.xop.msky130_fd_pr__pfet_g5v0d10v5[id] @m.x1.xa.xon.msky130_fd_pr__nfet_g5v0d10v5[id]
destroy all
alter vref dc=1.0
alter rl 1000
dc vd -2 2 0.02
wrdata ../build/d2s_dc_ff_T-40_V3.3_vr1_r1k.txt v(pad) v(vref) i(vdd) @m.x1.xa.xop.msky130_fd_pr__pfet_g5v0d10v5[id] @m.x1.xa.xon.msky130_fd_pr__nfet_g5v0d10v5[id]
destroy all
alter rl 1e+09
dc vd -2 2 0.02
wrdata ../build/d2s_dc_ff_T-40_V3.3_vr1_open.txt v(pad) v(vref) i(vdd) @m.x1.xa.xop.msky130_fd_pr__pfet_g5v0d10v5[id] @m.x1.xa.xon.msky130_fd_pr__nfet_g5v0d10v5[id]
destroy all
alter vref dc=1.1
alter rl 1000
dc vd -2 2 0.02
wrdata ../build/d2s_dc_ff_T-40_V3.3_vr1.1_r1k.txt v(pad) v(vref) i(vdd) @m.x1.xa.xop.msky130_fd_pr__pfet_g5v0d10v5[id] @m.x1.xa.xon.msky130_fd_pr__nfet_g5v0d10v5[id]
destroy all
alter rl 1e+09
dc vd -2 2 0.02
wrdata ../build/d2s_dc_ff_T-40_V3.3_vr1.1_open.txt v(pad) v(vref) i(vdd) @m.x1.xa.xop.msky130_fd_pr__pfet_g5v0d10v5[id] @m.x1.xa.xon.msky130_fd_pr__nfet_g5v0d10v5[id]
destroy all
alter vref dc=1.2
alter rl 1000
dc vd -2 2 0.02
wrdata ../build/d2s_dc_ff_T-40_V3.3_vr1.2_r1k.txt v(pad) v(vref) i(vdd) @m.x1.xa.xop.msky130_fd_pr__pfet_g5v0d10v5[id] @m.x1.xa.xon.msky130_fd_pr__nfet_g5v0d10v5[id]
destroy all
alter rl 1e+09
dc vd -2 2 0.02
wrdata ../build/d2s_dc_ff_T-40_V3.3_vr1.2_open.txt v(pad) v(vref) i(vdd) @m.x1.xa.xop.msky130_fd_pr__pfet_g5v0d10v5[id] @m.x1.xa.xon.msky130_fd_pr__nfet_g5v0d10v5[id]
destroy all
alter vref dc=1.3
alter rl 1000
dc vd -2 2 0.02
wrdata ../build/d2s_dc_ff_T-40_V3.3_vr1.3_r1k.txt v(pad) v(vref) i(vdd) @m.x1.xa.xop.msky130_fd_pr__pfet_g5v0d10v5[id] @m.x1.xa.xon.msky130_fd_pr__nfet_g5v0d10v5[id]
destroy all
alter rl 1e+09
dc vd -2 2 0.02
wrdata ../build/d2s_dc_ff_T-40_V3.3_vr1.3_open.txt v(pad) v(vref) i(vdd) @m.x1.xa.xop.msky130_fd_pr__pfet_g5v0d10v5[id] @m.x1.xa.xon.msky130_fd_pr__nfet_g5v0d10v5[id]
destroy all
alter vref dc=1.4
alter rl 1000
dc vd -2 2 0.02
wrdata ../build/d2s_dc_ff_T-40_V3.3_vr1.4_r1k.txt v(pad) v(vref) i(vdd) @m.x1.xa.xop.msky130_fd_pr__pfet_g5v0d10v5[id] @m.x1.xa.xon.msky130_fd_pr__nfet_g5v0d10v5[id]
destroy all
alter rl 1e+09
dc vd -2 2 0.02
wrdata ../build/d2s_dc_ff_T-40_V3.3_vr1.4_open.txt v(pad) v(vref) i(vdd) @m.x1.xa.xop.msky130_fd_pr__pfet_g5v0d10v5[id] @m.x1.xa.xon.msky130_fd_pr__nfet_g5v0d10v5[id]
destroy all
alter vref dc=1.5
alter rl 1000
dc vd -2 2 0.02
wrdata ../build/d2s_dc_ff_T-40_V3.3_vr1.5_r1k.txt v(pad) v(vref) i(vdd) @m.x1.xa.xop.msky130_fd_pr__pfet_g5v0d10v5[id] @m.x1.xa.xon.msky130_fd_pr__nfet_g5v0d10v5[id]
destroy all
alter rl 1e+09
dc vd -2 2 0.02
wrdata ../build/d2s_dc_ff_T-40_V3.3_vr1.5_open.txt v(pad) v(vref) i(vdd) @m.x1.xa.xop.msky130_fd_pr__pfet_g5v0d10v5[id] @m.x1.xa.xon.msky130_fd_pr__nfet_g5v0d10v5[id]
destroy all
alter vref dc=1.26
alter rl 1000
dc vd -2 2 0.02
wrdata ../build/d2s_dc_ff_T-40_V3.3_vr1.26_r1k.txt v(pad) v(vref) i(vdd) @m.x1.xa.xop.msky130_fd_pr__pfet_g5v0d10v5[id] @m.x1.xa.xon.msky130_fd_pr__nfet_g5v0d10v5[id]
destroy all
alter rl 1e+09
dc vd -2 2 0.02
wrdata ../build/d2s_dc_ff_T-40_V3.3_vr1.26_open.txt v(pad) v(vref) i(vdd) @m.x1.xa.xop.msky130_fd_pr__pfet_g5v0d10v5[id] @m.x1.xa.xon.msky130_fd_pr__nfet_g5v0d10v5[id]
destroy all
alter vdd dc=3.6
alter vref dc=0.9
alter rl 1000
dc vd -2 2 0.02
wrdata ../build/d2s_dc_ff_T-40_V3.6_vr0.9_r1k.txt v(pad) v(vref) i(vdd) @m.x1.xa.xop.msky130_fd_pr__pfet_g5v0d10v5[id] @m.x1.xa.xon.msky130_fd_pr__nfet_g5v0d10v5[id]
destroy all
alter rl 1e+09
dc vd -2 2 0.02
wrdata ../build/d2s_dc_ff_T-40_V3.6_vr0.9_open.txt v(pad) v(vref) i(vdd) @m.x1.xa.xop.msky130_fd_pr__pfet_g5v0d10v5[id] @m.x1.xa.xon.msky130_fd_pr__nfet_g5v0d10v5[id]
destroy all
alter vref dc=1.0
alter rl 1000
dc vd -2 2 0.02
wrdata ../build/d2s_dc_ff_T-40_V3.6_vr1_r1k.txt v(pad) v(vref) i(vdd) @m.x1.xa.xop.msky130_fd_pr__pfet_g5v0d10v5[id] @m.x1.xa.xon.msky130_fd_pr__nfet_g5v0d10v5[id]
destroy all
alter rl 1e+09
dc vd -2 2 0.02
wrdata ../build/d2s_dc_ff_T-40_V3.6_vr1_open.txt v(pad) v(vref) i(vdd) @m.x1.xa.xop.msky130_fd_pr__pfet_g5v0d10v5[id] @m.x1.xa.xon.msky130_fd_pr__nfet_g5v0d10v5[id]
destroy all
alter vref dc=1.1
alter rl 1000
dc vd -2 2 0.02
wrdata ../build/d2s_dc_ff_T-40_V3.6_vr1.1_r1k.txt v(pad) v(vref) i(vdd) @m.x1.xa.xop.msky130_fd_pr__pfet_g5v0d10v5[id] @m.x1.xa.xon.msky130_fd_pr__nfet_g5v0d10v5[id]
destroy all
alter rl 1e+09
dc vd -2 2 0.02
wrdata ../build/d2s_dc_ff_T-40_V3.6_vr1.1_open.txt v(pad) v(vref) i(vdd) @m.x1.xa.xop.msky130_fd_pr__pfet_g5v0d10v5[id] @m.x1.xa.xon.msky130_fd_pr__nfet_g5v0d10v5[id]
destroy all
alter vref dc=1.2
alter rl 1000
dc vd -2 2 0.02
wrdata ../build/d2s_dc_ff_T-40_V3.6_vr1.2_r1k.txt v(pad) v(vref) i(vdd) @m.x1.xa.xop.msky130_fd_pr__pfet_g5v0d10v5[id] @m.x1.xa.xon.msky130_fd_pr__nfet_g5v0d10v5[id]
destroy all
alter rl 1e+09
dc vd -2 2 0.02
wrdata ../build/d2s_dc_ff_T-40_V3.6_vr1.2_open.txt v(pad) v(vref) i(vdd) @m.x1.xa.xop.msky130_fd_pr__pfet_g5v0d10v5[id] @m.x1.xa.xon.msky130_fd_pr__nfet_g5v0d10v5[id]
destroy all
alter vref dc=1.3
alter rl 1000
dc vd -2 2 0.02
wrdata ../build/d2s_dc_ff_T-40_V3.6_vr1.3_r1k.txt v(pad) v(vref) i(vdd) @m.x1.xa.xop.msky130_fd_pr__pfet_g5v0d10v5[id] @m.x1.xa.xon.msky130_fd_pr__nfet_g5v0d10v5[id]
destroy all
alter rl 1e+09
dc vd -2 2 0.02
wrdata ../build/d2s_dc_ff_T-40_V3.6_vr1.3_open.txt v(pad) v(vref) i(vdd) @m.x1.xa.xop.msky130_fd_pr__pfet_g5v0d10v5[id] @m.x1.xa.xon.msky130_fd_pr__nfet_g5v0d10v5[id]
destroy all
alter vref dc=1.4
alter rl 1000
dc vd -2 2 0.02
wrdata ../build/d2s_dc_ff_T-40_V3.6_vr1.4_r1k.txt v(pad) v(vref) i(vdd) @m.x1.xa.xop.msky130_fd_pr__pfet_g5v0d10v5[id] @m.x1.xa.xon.msky130_fd_pr__nfet_g5v0d10v5[id]
destroy all
alter rl 1e+09
dc vd -2 2 0.02
wrdata ../build/d2s_dc_ff_T-40_V3.6_vr1.4_open.txt v(pad) v(vref) i(vdd) @m.x1.xa.xop.msky130_fd_pr__pfet_g5v0d10v5[id] @m.x1.xa.xon.msky130_fd_pr__nfet_g5v0d10v5[id]
destroy all
alter vref dc=1.5
alter rl 1000
dc vd -2 2 0.02
wrdata ../build/d2s_dc_ff_T-40_V3.6_vr1.5_r1k.txt v(pad) v(vref) i(vdd) @m.x1.xa.xop.msky130_fd_pr__pfet_g5v0d10v5[id] @m.x1.xa.xon.msky130_fd_pr__nfet_g5v0d10v5[id]
destroy all
alter rl 1e+09
dc vd -2 2 0.02
wrdata ../build/d2s_dc_ff_T-40_V3.6_vr1.5_open.txt v(pad) v(vref) i(vdd) @m.x1.xa.xop.msky130_fd_pr__pfet_g5v0d10v5[id] @m.x1.xa.xon.msky130_fd_pr__nfet_g5v0d10v5[id]
destroy all
alter vref dc=1.26
alter rl 1000
dc vd -2 2 0.02
wrdata ../build/d2s_dc_ff_T-40_V3.6_vr1.26_r1k.txt v(pad) v(vref) i(vdd) @m.x1.xa.xop.msky130_fd_pr__pfet_g5v0d10v5[id] @m.x1.xa.xon.msky130_fd_pr__nfet_g5v0d10v5[id]
destroy all
alter rl 1e+09
dc vd -2 2 0.02
wrdata ../build/d2s_dc_ff_T-40_V3.6_vr1.26_open.txt v(pad) v(vref) i(vdd) @m.x1.xa.xop.msky130_fd_pr__pfet_g5v0d10v5[id] @m.x1.xa.xon.msky130_fd_pr__nfet_g5v0d10v5[id]
destroy all
option temp=27
alter vdd dc=3.0
alter vref dc=0.9
alter rl 1000
dc vd -2 2 0.02
wrdata ../build/d2s_dc_ff_T27_V3_vr0.9_r1k.txt v(pad) v(vref) i(vdd) @m.x1.xa.xop.msky130_fd_pr__pfet_g5v0d10v5[id] @m.x1.xa.xon.msky130_fd_pr__nfet_g5v0d10v5[id]
destroy all
alter rl 1e+09
dc vd -2 2 0.02
wrdata ../build/d2s_dc_ff_T27_V3_vr0.9_open.txt v(pad) v(vref) i(vdd) @m.x1.xa.xop.msky130_fd_pr__pfet_g5v0d10v5[id] @m.x1.xa.xon.msky130_fd_pr__nfet_g5v0d10v5[id]
destroy all
alter vref dc=1.0
alter rl 1000
dc vd -2 2 0.02
wrdata ../build/d2s_dc_ff_T27_V3_vr1_r1k.txt v(pad) v(vref) i(vdd) @m.x1.xa.xop.msky130_fd_pr__pfet_g5v0d10v5[id] @m.x1.xa.xon.msky130_fd_pr__nfet_g5v0d10v5[id]
destroy all
alter rl 1e+09
dc vd -2 2 0.02
wrdata ../build/d2s_dc_ff_T27_V3_vr1_open.txt v(pad) v(vref) i(vdd) @m.x1.xa.xop.msky130_fd_pr__pfet_g5v0d10v5[id] @m.x1.xa.xon.msky130_fd_pr__nfet_g5v0d10v5[id]
destroy all
alter vref dc=1.1
alter rl 1000
dc vd -2 2 0.02
wrdata ../build/d2s_dc_ff_T27_V3_vr1.1_r1k.txt v(pad) v(vref) i(vdd) @m.x1.xa.xop.msky130_fd_pr__pfet_g5v0d10v5[id] @m.x1.xa.xon.msky130_fd_pr__nfet_g5v0d10v5[id]
destroy all
alter rl 1e+09
dc vd -2 2 0.02
wrdata ../build/d2s_dc_ff_T27_V3_vr1.1_open.txt v(pad) v(vref) i(vdd) @m.x1.xa.xop.msky130_fd_pr__pfet_g5v0d10v5[id] @m.x1.xa.xon.msky130_fd_pr__nfet_g5v0d10v5[id]
destroy all
alter vref dc=1.2
alter rl 1000
dc vd -2 2 0.02
wrdata ../build/d2s_dc_ff_T27_V3_vr1.2_r1k.txt v(pad) v(vref) i(vdd) @m.x1.xa.xop.msky130_fd_pr__pfet_g5v0d10v5[id] @m.x1.xa.xon.msky130_fd_pr__nfet_g5v0d10v5[id]
destroy all
alter rl 1e+09
dc vd -2 2 0.02
wrdata ../build/d2s_dc_ff_T27_V3_vr1.2_open.txt v(pad) v(vref) i(vdd) @m.x1.xa.xop.msky130_fd_pr__pfet_g5v0d10v5[id] @m.x1.xa.xon.msky130_fd_pr__nfet_g5v0d10v5[id]
destroy all
alter vref dc=1.3
alter rl 1000
dc vd -2 2 0.02
wrdata ../build/d2s_dc_ff_T27_V3_vr1.3_r1k.txt v(pad) v(vref) i(vdd) @m.x1.xa.xop.msky130_fd_pr__pfet_g5v0d10v5[id] @m.x1.xa.xon.msky130_fd_pr__nfet_g5v0d10v5[id]
destroy all
alter rl 1e+09
dc vd -2 2 0.02
wrdata ../build/d2s_dc_ff_T27_V3_vr1.3_open.txt v(pad) v(vref) i(vdd) @m.x1.xa.xop.msky130_fd_pr__pfet_g5v0d10v5[id] @m.x1.xa.xon.msky130_fd_pr__nfet_g5v0d10v5[id]
destroy all
alter vref dc=1.4
alter rl 1000
dc vd -2 2 0.02
wrdata ../build/d2s_dc_ff_T27_V3_vr1.4_r1k.txt v(pad) v(vref) i(vdd) @m.x1.xa.xop.msky130_fd_pr__pfet_g5v0d10v5[id] @m.x1.xa.xon.msky130_fd_pr__nfet_g5v0d10v5[id]
destroy all
alter rl 1e+09
dc vd -2 2 0.02
wrdata ../build/d2s_dc_ff_T27_V3_vr1.4_open.txt v(pad) v(vref) i(vdd) @m.x1.xa.xop.msky130_fd_pr__pfet_g5v0d10v5[id] @m.x1.xa.xon.msky130_fd_pr__nfet_g5v0d10v5[id]
destroy all
alter vref dc=1.5
alter rl 1000
dc vd -2 2 0.02
wrdata ../build/d2s_dc_ff_T27_V3_vr1.5_r1k.txt v(pad) v(vref) i(vdd) @m.x1.xa.xop.msky130_fd_pr__pfet_g5v0d10v5[id] @m.x1.xa.xon.msky130_fd_pr__nfet_g5v0d10v5[id]
destroy all
alter rl 1e+09
dc vd -2 2 0.02
wrdata ../build/d2s_dc_ff_T27_V3_vr1.5_open.txt v(pad) v(vref) i(vdd) @m.x1.xa.xop.msky130_fd_pr__pfet_g5v0d10v5[id] @m.x1.xa.xon.msky130_fd_pr__nfet_g5v0d10v5[id]
destroy all
alter vref dc=1.26
alter rl 1000
dc vd -2 2 0.02
wrdata ../build/d2s_dc_ff_T27_V3_vr1.26_r1k.txt v(pad) v(vref) i(vdd) @m.x1.xa.xop.msky130_fd_pr__pfet_g5v0d10v5[id] @m.x1.xa.xon.msky130_fd_pr__nfet_g5v0d10v5[id]
destroy all
alter rl 1e+09
dc vd -2 2 0.02
wrdata ../build/d2s_dc_ff_T27_V3_vr1.26_open.txt v(pad) v(vref) i(vdd) @m.x1.xa.xop.msky130_fd_pr__pfet_g5v0d10v5[id] @m.x1.xa.xon.msky130_fd_pr__nfet_g5v0d10v5[id]
destroy all
alter vdd dc=3.3
alter vref dc=0.9
alter rl 1000
dc vd -2 2 0.02
wrdata ../build/d2s_dc_ff_T27_V3.3_vr0.9_r1k.txt v(pad) v(vref) i(vdd) @m.x1.xa.xop.msky130_fd_pr__pfet_g5v0d10v5[id] @m.x1.xa.xon.msky130_fd_pr__nfet_g5v0d10v5[id]
destroy all
alter rl 1e+09
dc vd -2 2 0.02
wrdata ../build/d2s_dc_ff_T27_V3.3_vr0.9_open.txt v(pad) v(vref) i(vdd) @m.x1.xa.xop.msky130_fd_pr__pfet_g5v0d10v5[id] @m.x1.xa.xon.msky130_fd_pr__nfet_g5v0d10v5[id]
destroy all
alter vref dc=1.0
alter rl 1000
dc vd -2 2 0.02
wrdata ../build/d2s_dc_ff_T27_V3.3_vr1_r1k.txt v(pad) v(vref) i(vdd) @m.x1.xa.xop.msky130_fd_pr__pfet_g5v0d10v5[id] @m.x1.xa.xon.msky130_fd_pr__nfet_g5v0d10v5[id]
destroy all
alter rl 1e+09
dc vd -2 2 0.02
wrdata ../build/d2s_dc_ff_T27_V3.3_vr1_open.txt v(pad) v(vref) i(vdd) @m.x1.xa.xop.msky130_fd_pr__pfet_g5v0d10v5[id] @m.x1.xa.xon.msky130_fd_pr__nfet_g5v0d10v5[id]
destroy all
alter vref dc=1.1
alter rl 1000
dc vd -2 2 0.02
wrdata ../build/d2s_dc_ff_T27_V3.3_vr1.1_r1k.txt v(pad) v(vref) i(vdd) @m.x1.xa.xop.msky130_fd_pr__pfet_g5v0d10v5[id] @m.x1.xa.xon.msky130_fd_pr__nfet_g5v0d10v5[id]
destroy all
alter rl 1e+09
dc vd -2 2 0.02
wrdata ../build/d2s_dc_ff_T27_V3.3_vr1.1_open.txt v(pad) v(vref) i(vdd) @m.x1.xa.xop.msky130_fd_pr__pfet_g5v0d10v5[id] @m.x1.xa.xon.msky130_fd_pr__nfet_g5v0d10v5[id]
destroy all
alter vref dc=1.2
alter rl 1000
dc vd -2 2 0.02
wrdata ../build/d2s_dc_ff_T27_V3.3_vr1.2_r1k.txt v(pad) v(vref) i(vdd) @m.x1.xa.xop.msky130_fd_pr__pfet_g5v0d10v5[id] @m.x1.xa.xon.msky130_fd_pr__nfet_g5v0d10v5[id]
destroy all
alter rl 1e+09
dc vd -2 2 0.02
wrdata ../build/d2s_dc_ff_T27_V3.3_vr1.2_open.txt v(pad) v(vref) i(vdd) @m.x1.xa.xop.msky130_fd_pr__pfet_g5v0d10v5[id] @m.x1.xa.xon.msky130_fd_pr__nfet_g5v0d10v5[id]
destroy all
alter vref dc=1.3
alter rl 1000
dc vd -2 2 0.02
wrdata ../build/d2s_dc_ff_T27_V3.3_vr1.3_r1k.txt v(pad) v(vref) i(vdd) @m.x1.xa.xop.msky130_fd_pr__pfet_g5v0d10v5[id] @m.x1.xa.xon.msky130_fd_pr__nfet_g5v0d10v5[id]
destroy all
alter rl 1e+09
dc vd -2 2 0.02
wrdata ../build/d2s_dc_ff_T27_V3.3_vr1.3_open.txt v(pad) v(vref) i(vdd) @m.x1.xa.xop.msky130_fd_pr__pfet_g5v0d10v5[id] @m.x1.xa.xon.msky130_fd_pr__nfet_g5v0d10v5[id]
destroy all
alter vref dc=1.4
alter rl 1000
dc vd -2 2 0.02
wrdata ../build/d2s_dc_ff_T27_V3.3_vr1.4_r1k.txt v(pad) v(vref) i(vdd) @m.x1.xa.xop.msky130_fd_pr__pfet_g5v0d10v5[id] @m.x1.xa.xon.msky130_fd_pr__nfet_g5v0d10v5[id]
destroy all
alter rl 1e+09
dc vd -2 2 0.02
wrdata ../build/d2s_dc_ff_T27_V3.3_vr1.4_open.txt v(pad) v(vref) i(vdd) @m.x1.xa.xop.msky130_fd_pr__pfet_g5v0d10v5[id] @m.x1.xa.xon.msky130_fd_pr__nfet_g5v0d10v5[id]
destroy all
alter vref dc=1.5
alter rl 1000
dc vd -2 2 0.02
wrdata ../build/d2s_dc_ff_T27_V3.3_vr1.5_r1k.txt v(pad) v(vref) i(vdd) @m.x1.xa.xop.msky130_fd_pr__pfet_g5v0d10v5[id] @m.x1.xa.xon.msky130_fd_pr__nfet_g5v0d10v5[id]
destroy all
alter rl 1e+09
dc vd -2 2 0.02
wrdata ../build/d2s_dc_ff_T27_V3.3_vr1.5_open.txt v(pad) v(vref) i(vdd) @m.x1.xa.xop.msky130_fd_pr__pfet_g5v0d10v5[id] @m.x1.xa.xon.msky130_fd_pr__nfet_g5v0d10v5[id]
destroy all
alter vref dc=1.26
alter rl 1000
dc vd -2 2 0.02
wrdata ../build/d2s_dc_ff_T27_V3.3_vr1.26_r1k.txt v(pad) v(vref) i(vdd) @m.x1.xa.xop.msky130_fd_pr__pfet_g5v0d10v5[id] @m.x1.xa.xon.msky130_fd_pr__nfet_g5v0d10v5[id]
destroy all
alter rl 1e+09
dc vd -2 2 0.02
wrdata ../build/d2s_dc_ff_T27_V3.3_vr1.26_open.txt v(pad) v(vref) i(vdd) @m.x1.xa.xop.msky130_fd_pr__pfet_g5v0d10v5[id] @m.x1.xa.xon.msky130_fd_pr__nfet_g5v0d10v5[id]
destroy all
alter vdd dc=3.6
alter vref dc=0.9
alter rl 1000
dc vd -2 2 0.02
wrdata ../build/d2s_dc_ff_T27_V3.6_vr0.9_r1k.txt v(pad) v(vref) i(vdd) @m.x1.xa.xop.msky130_fd_pr__pfet_g5v0d10v5[id] @m.x1.xa.xon.msky130_fd_pr__nfet_g5v0d10v5[id]
destroy all
alter rl 1e+09
dc vd -2 2 0.02
wrdata ../build/d2s_dc_ff_T27_V3.6_vr0.9_open.txt v(pad) v(vref) i(vdd) @m.x1.xa.xop.msky130_fd_pr__pfet_g5v0d10v5[id] @m.x1.xa.xon.msky130_fd_pr__nfet_g5v0d10v5[id]
destroy all
alter vref dc=1.0
alter rl 1000
dc vd -2 2 0.02
wrdata ../build/d2s_dc_ff_T27_V3.6_vr1_r1k.txt v(pad) v(vref) i(vdd) @m.x1.xa.xop.msky130_fd_pr__pfet_g5v0d10v5[id] @m.x1.xa.xon.msky130_fd_pr__nfet_g5v0d10v5[id]
destroy all
alter rl 1e+09
dc vd -2 2 0.02
wrdata ../build/d2s_dc_ff_T27_V3.6_vr1_open.txt v(pad) v(vref) i(vdd) @m.x1.xa.xop.msky130_fd_pr__pfet_g5v0d10v5[id] @m.x1.xa.xon.msky130_fd_pr__nfet_g5v0d10v5[id]
destroy all
alter vref dc=1.1
alter rl 1000
dc vd -2 2 0.02
wrdata ../build/d2s_dc_ff_T27_V3.6_vr1.1_r1k.txt v(pad) v(vref) i(vdd) @m.x1.xa.xop.msky130_fd_pr__pfet_g5v0d10v5[id] @m.x1.xa.xon.msky130_fd_pr__nfet_g5v0d10v5[id]
destroy all
alter rl 1e+09
dc vd -2 2 0.02
wrdata ../build/d2s_dc_ff_T27_V3.6_vr1.1_open.txt v(pad) v(vref) i(vdd) @m.x1.xa.xop.msky130_fd_pr__pfet_g5v0d10v5[id] @m.x1.xa.xon.msky130_fd_pr__nfet_g5v0d10v5[id]
destroy all
alter vref dc=1.2
alter rl 1000
dc vd -2 2 0.02
wrdata ../build/d2s_dc_ff_T27_V3.6_vr1.2_r1k.txt v(pad) v(vref) i(vdd) @m.x1.xa.xop.msky130_fd_pr__pfet_g5v0d10v5[id] @m.x1.xa.xon.msky130_fd_pr__nfet_g5v0d10v5[id]
destroy all
alter rl 1e+09
dc vd -2 2 0.02
wrdata ../build/d2s_dc_ff_T27_V3.6_vr1.2_open.txt v(pad) v(vref) i(vdd) @m.x1.xa.xop.msky130_fd_pr__pfet_g5v0d10v5[id] @m.x1.xa.xon.msky130_fd_pr__nfet_g5v0d10v5[id]
destroy all
alter vref dc=1.3
alter rl 1000
dc vd -2 2 0.02
wrdata ../build/d2s_dc_ff_T27_V3.6_vr1.3_r1k.txt v(pad) v(vref) i(vdd) @m.x1.xa.xop.msky130_fd_pr__pfet_g5v0d10v5[id] @m.x1.xa.xon.msky130_fd_pr__nfet_g5v0d10v5[id]
destroy all
alter rl 1e+09
dc vd -2 2 0.02
wrdata ../build/d2s_dc_ff_T27_V3.6_vr1.3_open.txt v(pad) v(vref) i(vdd) @m.x1.xa.xop.msky130_fd_pr__pfet_g5v0d10v5[id] @m.x1.xa.xon.msky130_fd_pr__nfet_g5v0d10v5[id]
destroy all
alter vref dc=1.4
alter rl 1000
dc vd -2 2 0.02
wrdata ../build/d2s_dc_ff_T27_V3.6_vr1.4_r1k.txt v(pad) v(vref) i(vdd) @m.x1.xa.xop.msky130_fd_pr__pfet_g5v0d10v5[id] @m.x1.xa.xon.msky130_fd_pr__nfet_g5v0d10v5[id]
destroy all
alter rl 1e+09
dc vd -2 2 0.02
wrdata ../build/d2s_dc_ff_T27_V3.6_vr1.4_open.txt v(pad) v(vref) i(vdd) @m.x1.xa.xop.msky130_fd_pr__pfet_g5v0d10v5[id] @m.x1.xa.xon.msky130_fd_pr__nfet_g5v0d10v5[id]
destroy all
alter vref dc=1.5
alter rl 1000
dc vd -2 2 0.02
wrdata ../build/d2s_dc_ff_T27_V3.6_vr1.5_r1k.txt v(pad) v(vref) i(vdd) @m.x1.xa.xop.msky130_fd_pr__pfet_g5v0d10v5[id] @m.x1.xa.xon.msky130_fd_pr__nfet_g5v0d10v5[id]
destroy all
alter rl 1e+09
dc vd -2 2 0.02
wrdata ../build/d2s_dc_ff_T27_V3.6_vr1.5_open.txt v(pad) v(vref) i(vdd) @m.x1.xa.xop.msky130_fd_pr__pfet_g5v0d10v5[id] @m.x1.xa.xon.msky130_fd_pr__nfet_g5v0d10v5[id]
destroy all
alter vref dc=1.26
alter rl 1000
dc vd -2 2 0.02
wrdata ../build/d2s_dc_ff_T27_V3.6_vr1.26_r1k.txt v(pad) v(vref) i(vdd) @m.x1.xa.xop.msky130_fd_pr__pfet_g5v0d10v5[id] @m.x1.xa.xon.msky130_fd_pr__nfet_g5v0d10v5[id]
destroy all
alter rl 1e+09
dc vd -2 2 0.02
wrdata ../build/d2s_dc_ff_T27_V3.6_vr1.26_open.txt v(pad) v(vref) i(vdd) @m.x1.xa.xop.msky130_fd_pr__pfet_g5v0d10v5[id] @m.x1.xa.xon.msky130_fd_pr__nfet_g5v0d10v5[id]
destroy all
option temp=125
alter vdd dc=3.0
alter vref dc=0.9
alter rl 1000
dc vd -2 2 0.02
wrdata ../build/d2s_dc_ff_T125_V3_vr0.9_r1k.txt v(pad) v(vref) i(vdd) @m.x1.xa.xop.msky130_fd_pr__pfet_g5v0d10v5[id] @m.x1.xa.xon.msky130_fd_pr__nfet_g5v0d10v5[id]
destroy all
alter rl 1e+09
dc vd -2 2 0.02
wrdata ../build/d2s_dc_ff_T125_V3_vr0.9_open.txt v(pad) v(vref) i(vdd) @m.x1.xa.xop.msky130_fd_pr__pfet_g5v0d10v5[id] @m.x1.xa.xon.msky130_fd_pr__nfet_g5v0d10v5[id]
destroy all
alter vref dc=1.0
alter rl 1000
dc vd -2 2 0.02
wrdata ../build/d2s_dc_ff_T125_V3_vr1_r1k.txt v(pad) v(vref) i(vdd) @m.x1.xa.xop.msky130_fd_pr__pfet_g5v0d10v5[id] @m.x1.xa.xon.msky130_fd_pr__nfet_g5v0d10v5[id]
destroy all
alter rl 1e+09
dc vd -2 2 0.02
wrdata ../build/d2s_dc_ff_T125_V3_vr1_open.txt v(pad) v(vref) i(vdd) @m.x1.xa.xop.msky130_fd_pr__pfet_g5v0d10v5[id] @m.x1.xa.xon.msky130_fd_pr__nfet_g5v0d10v5[id]
destroy all
alter vref dc=1.1
alter rl 1000
dc vd -2 2 0.02
wrdata ../build/d2s_dc_ff_T125_V3_vr1.1_r1k.txt v(pad) v(vref) i(vdd) @m.x1.xa.xop.msky130_fd_pr__pfet_g5v0d10v5[id] @m.x1.xa.xon.msky130_fd_pr__nfet_g5v0d10v5[id]
destroy all
alter rl 1e+09
dc vd -2 2 0.02
wrdata ../build/d2s_dc_ff_T125_V3_vr1.1_open.txt v(pad) v(vref) i(vdd) @m.x1.xa.xop.msky130_fd_pr__pfet_g5v0d10v5[id] @m.x1.xa.xon.msky130_fd_pr__nfet_g5v0d10v5[id]
destroy all
alter vref dc=1.2
alter rl 1000
dc vd -2 2 0.02
wrdata ../build/d2s_dc_ff_T125_V3_vr1.2_r1k.txt v(pad) v(vref) i(vdd) @m.x1.xa.xop.msky130_fd_pr__pfet_g5v0d10v5[id] @m.x1.xa.xon.msky130_fd_pr__nfet_g5v0d10v5[id]
destroy all
alter rl 1e+09
dc vd -2 2 0.02
wrdata ../build/d2s_dc_ff_T125_V3_vr1.2_open.txt v(pad) v(vref) i(vdd) @m.x1.xa.xop.msky130_fd_pr__pfet_g5v0d10v5[id] @m.x1.xa.xon.msky130_fd_pr__nfet_g5v0d10v5[id]
destroy all
alter vref dc=1.3
alter rl 1000
dc vd -2 2 0.02
wrdata ../build/d2s_dc_ff_T125_V3_vr1.3_r1k.txt v(pad) v(vref) i(vdd) @m.x1.xa.xop.msky130_fd_pr__pfet_g5v0d10v5[id] @m.x1.xa.xon.msky130_fd_pr__nfet_g5v0d10v5[id]
destroy all
alter rl 1e+09
dc vd -2 2 0.02
wrdata ../build/d2s_dc_ff_T125_V3_vr1.3_open.txt v(pad) v(vref) i(vdd) @m.x1.xa.xop.msky130_fd_pr__pfet_g5v0d10v5[id] @m.x1.xa.xon.msky130_fd_pr__nfet_g5v0d10v5[id]
destroy all
alter vref dc=1.4
alter rl 1000
dc vd -2 2 0.02
wrdata ../build/d2s_dc_ff_T125_V3_vr1.4_r1k.txt v(pad) v(vref) i(vdd) @m.x1.xa.xop.msky130_fd_pr__pfet_g5v0d10v5[id] @m.x1.xa.xon.msky130_fd_pr__nfet_g5v0d10v5[id]
destroy all
alter rl 1e+09
dc vd -2 2 0.02
wrdata ../build/d2s_dc_ff_T125_V3_vr1.4_open.txt v(pad) v(vref) i(vdd) @m.x1.xa.xop.msky130_fd_pr__pfet_g5v0d10v5[id] @m.x1.xa.xon.msky130_fd_pr__nfet_g5v0d10v5[id]
destroy all
alter vref dc=1.5
alter rl 1000
dc vd -2 2 0.02
wrdata ../build/d2s_dc_ff_T125_V3_vr1.5_r1k.txt v(pad) v(vref) i(vdd) @m.x1.xa.xop.msky130_fd_pr__pfet_g5v0d10v5[id] @m.x1.xa.xon.msky130_fd_pr__nfet_g5v0d10v5[id]
destroy all
alter rl 1e+09
dc vd -2 2 0.02
wrdata ../build/d2s_dc_ff_T125_V3_vr1.5_open.txt v(pad) v(vref) i(vdd) @m.x1.xa.xop.msky130_fd_pr__pfet_g5v0d10v5[id] @m.x1.xa.xon.msky130_fd_pr__nfet_g5v0d10v5[id]
destroy all
alter vref dc=1.26
alter rl 1000
dc vd -2 2 0.02
wrdata ../build/d2s_dc_ff_T125_V3_vr1.26_r1k.txt v(pad) v(vref) i(vdd) @m.x1.xa.xop.msky130_fd_pr__pfet_g5v0d10v5[id] @m.x1.xa.xon.msky130_fd_pr__nfet_g5v0d10v5[id]
destroy all
alter rl 1e+09
dc vd -2 2 0.02
wrdata ../build/d2s_dc_ff_T125_V3_vr1.26_open.txt v(pad) v(vref) i(vdd) @m.x1.xa.xop.msky130_fd_pr__pfet_g5v0d10v5[id] @m.x1.xa.xon.msky130_fd_pr__nfet_g5v0d10v5[id]
destroy all
alter vdd dc=3.3
alter vref dc=0.9
alter rl 1000
dc vd -2 2 0.02
wrdata ../build/d2s_dc_ff_T125_V3.3_vr0.9_r1k.txt v(pad) v(vref) i(vdd) @m.x1.xa.xop.msky130_fd_pr__pfet_g5v0d10v5[id] @m.x1.xa.xon.msky130_fd_pr__nfet_g5v0d10v5[id]
destroy all
alter rl 1e+09
dc vd -2 2 0.02
wrdata ../build/d2s_dc_ff_T125_V3.3_vr0.9_open.txt v(pad) v(vref) i(vdd) @m.x1.xa.xop.msky130_fd_pr__pfet_g5v0d10v5[id] @m.x1.xa.xon.msky130_fd_pr__nfet_g5v0d10v5[id]
destroy all
alter vref dc=1.0
alter rl 1000
dc vd -2 2 0.02
wrdata ../build/d2s_dc_ff_T125_V3.3_vr1_r1k.txt v(pad) v(vref) i(vdd) @m.x1.xa.xop.msky130_fd_pr__pfet_g5v0d10v5[id] @m.x1.xa.xon.msky130_fd_pr__nfet_g5v0d10v5[id]
destroy all
alter rl 1e+09
dc vd -2 2 0.02
wrdata ../build/d2s_dc_ff_T125_V3.3_vr1_open.txt v(pad) v(vref) i(vdd) @m.x1.xa.xop.msky130_fd_pr__pfet_g5v0d10v5[id] @m.x1.xa.xon.msky130_fd_pr__nfet_g5v0d10v5[id]
destroy all
alter vref dc=1.1
alter rl 1000
dc vd -2 2 0.02
wrdata ../build/d2s_dc_ff_T125_V3.3_vr1.1_r1k.txt v(pad) v(vref) i(vdd) @m.x1.xa.xop.msky130_fd_pr__pfet_g5v0d10v5[id] @m.x1.xa.xon.msky130_fd_pr__nfet_g5v0d10v5[id]
destroy all
alter rl 1e+09
dc vd -2 2 0.02
wrdata ../build/d2s_dc_ff_T125_V3.3_vr1.1_open.txt v(pad) v(vref) i(vdd) @m.x1.xa.xop.msky130_fd_pr__pfet_g5v0d10v5[id] @m.x1.xa.xon.msky130_fd_pr__nfet_g5v0d10v5[id]
destroy all
alter vref dc=1.2
alter rl 1000
dc vd -2 2 0.02
wrdata ../build/d2s_dc_ff_T125_V3.3_vr1.2_r1k.txt v(pad) v(vref) i(vdd) @m.x1.xa.xop.msky130_fd_pr__pfet_g5v0d10v5[id] @m.x1.xa.xon.msky130_fd_pr__nfet_g5v0d10v5[id]
destroy all
alter rl 1e+09
dc vd -2 2 0.02
wrdata ../build/d2s_dc_ff_T125_V3.3_vr1.2_open.txt v(pad) v(vref) i(vdd) @m.x1.xa.xop.msky130_fd_pr__pfet_g5v0d10v5[id] @m.x1.xa.xon.msky130_fd_pr__nfet_g5v0d10v5[id]
destroy all
alter vref dc=1.3
alter rl 1000
dc vd -2 2 0.02
wrdata ../build/d2s_dc_ff_T125_V3.3_vr1.3_r1k.txt v(pad) v(vref) i(vdd) @m.x1.xa.xop.msky130_fd_pr__pfet_g5v0d10v5[id] @m.x1.xa.xon.msky130_fd_pr__nfet_g5v0d10v5[id]
destroy all
alter rl 1e+09
dc vd -2 2 0.02
wrdata ../build/d2s_dc_ff_T125_V3.3_vr1.3_open.txt v(pad) v(vref) i(vdd) @m.x1.xa.xop.msky130_fd_pr__pfet_g5v0d10v5[id] @m.x1.xa.xon.msky130_fd_pr__nfet_g5v0d10v5[id]
destroy all
alter vref dc=1.4
alter rl 1000
dc vd -2 2 0.02
wrdata ../build/d2s_dc_ff_T125_V3.3_vr1.4_r1k.txt v(pad) v(vref) i(vdd) @m.x1.xa.xop.msky130_fd_pr__pfet_g5v0d10v5[id] @m.x1.xa.xon.msky130_fd_pr__nfet_g5v0d10v5[id]
destroy all
alter rl 1e+09
dc vd -2 2 0.02
wrdata ../build/d2s_dc_ff_T125_V3.3_vr1.4_open.txt v(pad) v(vref) i(vdd) @m.x1.xa.xop.msky130_fd_pr__pfet_g5v0d10v5[id] @m.x1.xa.xon.msky130_fd_pr__nfet_g5v0d10v5[id]
destroy all
alter vref dc=1.5
alter rl 1000
dc vd -2 2 0.02
wrdata ../build/d2s_dc_ff_T125_V3.3_vr1.5_r1k.txt v(pad) v(vref) i(vdd) @m.x1.xa.xop.msky130_fd_pr__pfet_g5v0d10v5[id] @m.x1.xa.xon.msky130_fd_pr__nfet_g5v0d10v5[id]
destroy all
alter rl 1e+09
dc vd -2 2 0.02
wrdata ../build/d2s_dc_ff_T125_V3.3_vr1.5_open.txt v(pad) v(vref) i(vdd) @m.x1.xa.xop.msky130_fd_pr__pfet_g5v0d10v5[id] @m.x1.xa.xon.msky130_fd_pr__nfet_g5v0d10v5[id]
destroy all
alter vref dc=1.26
alter rl 1000
dc vd -2 2 0.02
wrdata ../build/d2s_dc_ff_T125_V3.3_vr1.26_r1k.txt v(pad) v(vref) i(vdd) @m.x1.xa.xop.msky130_fd_pr__pfet_g5v0d10v5[id] @m.x1.xa.xon.msky130_fd_pr__nfet_g5v0d10v5[id]
destroy all
alter rl 1e+09
dc vd -2 2 0.02
wrdata ../build/d2s_dc_ff_T125_V3.3_vr1.26_open.txt v(pad) v(vref) i(vdd) @m.x1.xa.xop.msky130_fd_pr__pfet_g5v0d10v5[id] @m.x1.xa.xon.msky130_fd_pr__nfet_g5v0d10v5[id]
destroy all
alter vdd dc=3.6
alter vref dc=0.9
alter rl 1000
dc vd -2 2 0.02
wrdata ../build/d2s_dc_ff_T125_V3.6_vr0.9_r1k.txt v(pad) v(vref) i(vdd) @m.x1.xa.xop.msky130_fd_pr__pfet_g5v0d10v5[id] @m.x1.xa.xon.msky130_fd_pr__nfet_g5v0d10v5[id]
destroy all
alter rl 1e+09
dc vd -2 2 0.02
wrdata ../build/d2s_dc_ff_T125_V3.6_vr0.9_open.txt v(pad) v(vref) i(vdd) @m.x1.xa.xop.msky130_fd_pr__pfet_g5v0d10v5[id] @m.x1.xa.xon.msky130_fd_pr__nfet_g5v0d10v5[id]
destroy all
alter vref dc=1.0
alter rl 1000
dc vd -2 2 0.02
wrdata ../build/d2s_dc_ff_T125_V3.6_vr1_r1k.txt v(pad) v(vref) i(vdd) @m.x1.xa.xop.msky130_fd_pr__pfet_g5v0d10v5[id] @m.x1.xa.xon.msky130_fd_pr__nfet_g5v0d10v5[id]
destroy all
alter rl 1e+09
dc vd -2 2 0.02
wrdata ../build/d2s_dc_ff_T125_V3.6_vr1_open.txt v(pad) v(vref) i(vdd) @m.x1.xa.xop.msky130_fd_pr__pfet_g5v0d10v5[id] @m.x1.xa.xon.msky130_fd_pr__nfet_g5v0d10v5[id]
destroy all
alter vref dc=1.1
alter rl 1000
dc vd -2 2 0.02
wrdata ../build/d2s_dc_ff_T125_V3.6_vr1.1_r1k.txt v(pad) v(vref) i(vdd) @m.x1.xa.xop.msky130_fd_pr__pfet_g5v0d10v5[id] @m.x1.xa.xon.msky130_fd_pr__nfet_g5v0d10v5[id]
destroy all
alter rl 1e+09
dc vd -2 2 0.02
wrdata ../build/d2s_dc_ff_T125_V3.6_vr1.1_open.txt v(pad) v(vref) i(vdd) @m.x1.xa.xop.msky130_fd_pr__pfet_g5v0d10v5[id] @m.x1.xa.xon.msky130_fd_pr__nfet_g5v0d10v5[id]
destroy all
alter vref dc=1.2
alter rl 1000
dc vd -2 2 0.02
wrdata ../build/d2s_dc_ff_T125_V3.6_vr1.2_r1k.txt v(pad) v(vref) i(vdd) @m.x1.xa.xop.msky130_fd_pr__pfet_g5v0d10v5[id] @m.x1.xa.xon.msky130_fd_pr__nfet_g5v0d10v5[id]
destroy all
alter rl 1e+09
dc vd -2 2 0.02
wrdata ../build/d2s_dc_ff_T125_V3.6_vr1.2_open.txt v(pad) v(vref) i(vdd) @m.x1.xa.xop.msky130_fd_pr__pfet_g5v0d10v5[id] @m.x1.xa.xon.msky130_fd_pr__nfet_g5v0d10v5[id]
destroy all
alter vref dc=1.3
alter rl 1000
dc vd -2 2 0.02
wrdata ../build/d2s_dc_ff_T125_V3.6_vr1.3_r1k.txt v(pad) v(vref) i(vdd) @m.x1.xa.xop.msky130_fd_pr__pfet_g5v0d10v5[id] @m.x1.xa.xon.msky130_fd_pr__nfet_g5v0d10v5[id]
destroy all
alter rl 1e+09
dc vd -2 2 0.02
wrdata ../build/d2s_dc_ff_T125_V3.6_vr1.3_open.txt v(pad) v(vref) i(vdd) @m.x1.xa.xop.msky130_fd_pr__pfet_g5v0d10v5[id] @m.x1.xa.xon.msky130_fd_pr__nfet_g5v0d10v5[id]
destroy all
alter vref dc=1.4
alter rl 1000
dc vd -2 2 0.02
wrdata ../build/d2s_dc_ff_T125_V3.6_vr1.4_r1k.txt v(pad) v(vref) i(vdd) @m.x1.xa.xop.msky130_fd_pr__pfet_g5v0d10v5[id] @m.x1.xa.xon.msky130_fd_pr__nfet_g5v0d10v5[id]
destroy all
alter rl 1e+09
dc vd -2 2 0.02
wrdata ../build/d2s_dc_ff_T125_V3.6_vr1.4_open.txt v(pad) v(vref) i(vdd) @m.x1.xa.xop.msky130_fd_pr__pfet_g5v0d10v5[id] @m.x1.xa.xon.msky130_fd_pr__nfet_g5v0d10v5[id]
destroy all
alter vref dc=1.5
alter rl 1000
dc vd -2 2 0.02
wrdata ../build/d2s_dc_ff_T125_V3.6_vr1.5_r1k.txt v(pad) v(vref) i(vdd) @m.x1.xa.xop.msky130_fd_pr__pfet_g5v0d10v5[id] @m.x1.xa.xon.msky130_fd_pr__nfet_g5v0d10v5[id]
destroy all
alter rl 1e+09
dc vd -2 2 0.02
wrdata ../build/d2s_dc_ff_T125_V3.6_vr1.5_open.txt v(pad) v(vref) i(vdd) @m.x1.xa.xop.msky130_fd_pr__pfet_g5v0d10v5[id] @m.x1.xa.xon.msky130_fd_pr__nfet_g5v0d10v5[id]
destroy all
alter vref dc=1.26
alter rl 1000
dc vd -2 2 0.02
wrdata ../build/d2s_dc_ff_T125_V3.6_vr1.26_r1k.txt v(pad) v(vref) i(vdd) @m.x1.xa.xop.msky130_fd_pr__pfet_g5v0d10v5[id] @m.x1.xa.xon.msky130_fd_pr__nfet_g5v0d10v5[id]
destroy all
alter rl 1e+09
dc vd -2 2 0.02
wrdata ../build/d2s_dc_ff_T125_V3.6_vr1.26_open.txt v(pad) v(vref) i(vdd) @m.x1.xa.xop.msky130_fd_pr__pfet_g5v0d10v5[id] @m.x1.xa.xon.msky130_fd_pr__nfet_g5v0d10v5[id]
destroy all
.endc
.end
