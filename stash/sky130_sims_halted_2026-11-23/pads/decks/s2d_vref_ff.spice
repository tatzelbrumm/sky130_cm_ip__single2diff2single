* s2d_vref_ff: S2D core DC transfer vs vref, corner ff, 125 C, vcm = 1.05 V
* SPDX-FileCopyrightText: 2026 Christoph Maier
* SPDX-License-Identifier: Apache-2.0
* sky130 pre-layout schematic simulation (feasibility, not sign-off).
* Generated by scripts/gen_decks.py; regenerate rather than edit. Run from decks/: ngspice -b <deck>
* Pad swept 0 .. 1 V (10 mV); vref swept over the IHP replica's spread (0.436 .. 0.596 V over PVT).
.lib /foss/pdks/sky130A/libs.tech/ngspice/sky130.lib.spice ff
.include ../netlists/units_sky130.spice
.include ../netlists/s2d_core_sky130.spice
Vdd vdd 0 3.3
Vref vref 0 0.49
Vcm vcm 0 1.05
Vin vin 0 0.49
Iref vdd iref 5u
X1 vdd 0 vin vref vcm op on iref s2d_core_sky130
CLp op 0 5e-13
CLn on 0 5e-13
.control
set wr_singlescale
set wr_vecnames
option numdgt=8
option temp=125
alter vdd dc=3.0
alter vref dc=0.4
dc vin 0 1 0.01
wrdata ../build/s2d_vref_ff_T125_V3_vr0.4.txt v(op) v(on) i(vdd) v(vref)
destroy all
alter vref dc=0.45
dc vin 0 1 0.01
wrdata ../build/s2d_vref_ff_T125_V3_vr0.45.txt v(op) v(on) i(vdd) v(vref)
destroy all
alter vref dc=0.49
dc vin 0 1 0.01
wrdata ../build/s2d_vref_ff_T125_V3_vr0.49.txt v(op) v(on) i(vdd) v(vref)
destroy all
alter vref dc=0.55
dc vin 0 1 0.01
wrdata ../build/s2d_vref_ff_T125_V3_vr0.55.txt v(op) v(on) i(vdd) v(vref)
destroy all
alter vref dc=0.6
dc vin 0 1 0.01
wrdata ../build/s2d_vref_ff_T125_V3_vr0.6.txt v(op) v(on) i(vdd) v(vref)
destroy all
alter vdd dc=3.3
alter vref dc=0.4
dc vin 0 1 0.01
wrdata ../build/s2d_vref_ff_T125_V3.3_vr0.4.txt v(op) v(on) i(vdd) v(vref)
destroy all
alter vref dc=0.45
dc vin 0 1 0.01
wrdata ../build/s2d_vref_ff_T125_V3.3_vr0.45.txt v(op) v(on) i(vdd) v(vref)
destroy all
alter vref dc=0.49
dc vin 0 1 0.01
wrdata ../build/s2d_vref_ff_T125_V3.3_vr0.49.txt v(op) v(on) i(vdd) v(vref)
destroy all
alter vref dc=0.55
dc vin 0 1 0.01
wrdata ../build/s2d_vref_ff_T125_V3.3_vr0.55.txt v(op) v(on) i(vdd) v(vref)
destroy all
alter vref dc=0.6
dc vin 0 1 0.01
wrdata ../build/s2d_vref_ff_T125_V3.3_vr0.6.txt v(op) v(on) i(vdd) v(vref)
destroy all
alter vdd dc=3.6
alter vref dc=0.4
dc vin 0 1 0.01
wrdata ../build/s2d_vref_ff_T125_V3.6_vr0.4.txt v(op) v(on) i(vdd) v(vref)
destroy all
alter vref dc=0.45
dc vin 0 1 0.01
wrdata ../build/s2d_vref_ff_T125_V3.6_vr0.45.txt v(op) v(on) i(vdd) v(vref)
destroy all
alter vref dc=0.49
dc vin 0 1 0.01
wrdata ../build/s2d_vref_ff_T125_V3.6_vr0.49.txt v(op) v(on) i(vdd) v(vref)
destroy all
alter vref dc=0.55
dc vin 0 1 0.01
wrdata ../build/s2d_vref_ff_T125_V3.6_vr0.55.txt v(op) v(on) i(vdd) v(vref)
destroy all
alter vref dc=0.6
dc vin 0 1 0.01
wrdata ../build/s2d_vref_ff_T125_V3.6_vr0.6.txt v(op) v(on) i(vdd) v(vref)
destroy all
.endc
.end
