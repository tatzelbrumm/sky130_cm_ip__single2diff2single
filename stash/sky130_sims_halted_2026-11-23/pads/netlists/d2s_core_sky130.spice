* SPDX-FileCopyrightText: 2026 Christoph Maier
* SPDX-License-Identifier: Apache-2.0
*
* d2s_core_sky130: sky130 pre-layout port of the D2S core amplifier (IHP sg13cmos5l_cm_ip__single2diff2single
* commit 91a7da8b: macros/sg13cmos5l_IOPadDiff2Single/netlist/source/d2s_mpdda_pd.spice, d2s_out.spice,
* the Miller capacitors of sg13cmos5l_IOPadDiff2Single.spice, and macros/bias_tree_pd/netlist/source/
* bias_ref_pd.spice: bias_tree_pd). sky130 pre-layout schematic simulation (feasibility, not sign-off).
* No ESD, no pad, no 2 kOhm secondary stages in front of the Miller capacitors, no enable switches,
* no layout dummies.
*
* Function (unchanged from IHP): pad - vref = (vinp - vinn)/2.
*   MP-DDA: four matched units A (vinp, vref), B (vref, vinn), C1 = C2 (vref, vfb), vfb = pad;
*   balance f(vinp - vref) + f(vref - vinn) = 2 f(vfb - vref).
*   Folded cascode into a low-voltage cascode mirror; floating current source FPL / FNL (replica) and
*   floating class-AB control ABP / ABN between the output gates a (OP) and b (ON); class-AB bias by
*   the diode stacks RP1 + RP2 (vabp) and RN1 + RN2 (vabn); Miller capacitors CMA (a - pad), CMB (b - pad).
*
* Sizes vs IHP (g5v0d10v5 bins only; device rules in units_sky130.spice):
*   unit_r2                 see units_sky130.spice.
*   SX / SY  36/6 (ng 6)    -> nfet W=7 L=2 m=6          CX / CY 30/3 -> nfet W=7 L=2 m=4
*   PL / PR  24/4 (ng 4)    -> pfet W=7 L=4 m=4          PCL / PCR 30/3 -> pfet W=7 L=2 m=4
*   FPL / ABP / RP2  6.66/0.6 -> pfet W=5 L=0.6 m=1 (bin; W/L 8.3 vs 11.1)
*   FNL / ABN / RN2  4.4/1    -> nfet W=5 L=1 m=1 (W/L 5 vs 4.4)
*   OP  546/0.6 (82 fingers), RP1 13.32/0.6 (41 : 1) -> pfet W=10 L=0.5 m={mop} / m=1 (default 40 : 1)
*   ON  299/1   (68 fingers), RN1 8.8/1    (34 : 1)  -> nfet W=5 L=1 m={mon} / m=1  (default 40 : 1)
*            With 5 uA in each diode stack the quiescent output current is about 40 x 5 uA = 200 uA
*            (IHP about 207 uA). sky130 pfet L = 0.5 is the minimum of g5v0d10v5.
*   CMA / CMB hv PMOS accumulation capacitors 7.96u x 32.16u (about 1.2 pF) -> sky130_fd_pr__cap_mim_m3_1
*            {wcm} x {wcm} um (default 25: about 1.3 pF), linear.
*   Bias (bias_tree_pd without the enable gates): as s2d_bias_sky130 (s2d_core_sky130.spice) plus
*     NABP 6/6 -> nfet W=1 L=4 m=5 (sinks 5 uA from vabp), PABN 5/6 -> pfet W=7 L=2 m=2 (sources 5 uA into vabn).
*
* Pins: vdd vss vinp vinn vref pad iref (pad = output; vfb tied to pad inside). iref sourced into the cell, 5 uA.

.subckt d2s_bias_sky130 vdd vss iref vbp vbn vbpc vbnc vabp vabn wbnc=1 lbnc=4
XNI iref iref vss vss sky130_fd_pr__nfet_g5v0d10v5 W=1 L=4 m=5
XNBP vbp iref vss vss sky130_fd_pr__nfet_g5v0d10v5 W=1 L=4 m=5
XNBPC vbpc iref vss vss sky130_fd_pr__nfet_g5v0d10v5 W=1 L=4 m=2
XNABP vabp iref vss vss sky130_fd_pr__nfet_g5v0d10v5 W=1 L=4 m=5
XPBN vbn vbp vdd vdd sky130_fd_pr__pfet_g5v0d10v5 W=7 L=2 m=2
XPBNC vbnc vbp vdd vdd sky130_fd_pr__pfet_g5v0d10v5 W=7 L=2 m=1
XPABN vabn vbp vdd vdd sky130_fd_pr__pfet_g5v0d10v5 W=7 L=2 m=2
XBP vbp vbp vdd vdd sky130_fd_pr__pfet_g5v0d10v5 W=7 L=2 m=2
XBN vbn vbn vss vss sky130_fd_pr__nfet_g5v0d10v5 W=7 L=2 m=1
XBNC vbnc vbnc vss vss sky130_fd_pr__nfet_g5v0d10v5 W={wbnc} L={lbnc}
XBPC vbpc vbpc vdd vdd sky130_fd_pr__pfet_g5v0d10v5 W=1 L=4
.ends d2s_bias_sky130

.subckt d2s_mpdda_sky130 vdd vss vinp vinn vref vout vfb vbp vbn vbpc vbnc vabp vabn rl=26.2 mop=40 mon=40 wcm=25
XA x y vinp vref vdd vss vbp unit_r2 rl={rl}
XB x y vref vinn vdd vss vbp unit_r2 rl={rl}
XC1 x y vref vfb vdd vss vbp unit_r2 rl={rl}
XC2 x y vref vfb vdd vss vbp unit_r2 rl={rl}
* --- folded cascode (30 uA sinks: 4 x 5 uA from the units + 10 uA branch)
XSX x vbn vss vss sky130_fd_pr__nfet_g5v0d10v5 W=7 L=2 m=6
XSY y vbn vss vss sky130_fd_pr__nfet_g5v0d10v5 W=7 L=2 m=6
XCX l1 vbnc x vss sky130_fd_pr__nfet_g5v0d10v5 W=7 L=2 m=4
XCY b vbnc y vss sky130_fd_pr__nfet_g5v0d10v5 W=7 L=2 m=4
* --- low-voltage cascode mirror (10 uA per branch)
XPL pl l2 vdd vdd sky130_fd_pr__pfet_g5v0d10v5 W=7 L=4 m=4
XPR pr l2 vdd vdd sky130_fd_pr__pfet_g5v0d10v5 W=7 L=4 m=4
XPCL l2 vbpc pl vdd sky130_fd_pr__pfet_g5v0d10v5 W=7 L=2 m=4
XPCR a vbpc pr vdd sky130_fd_pr__pfet_g5v0d10v5 W=7 L=2 m=4
* --- floating current source (replica) and floating class-AB control
XFPL l1 vabp l2 vdd sky130_fd_pr__pfet_g5v0d10v5 W=5 L=0.6
XFNL l2 vabn l1 vss sky130_fd_pr__nfet_g5v0d10v5 W=5 L=1
XABP b vabp a vdd sky130_fd_pr__pfet_g5v0d10v5 W=5 L=0.6
XABN a vabn b vss sky130_fd_pr__nfet_g5v0d10v5 W=5 L=1
* --- class-AB diode stacks: RP2 / RN2 (replicas of ABP / ABN) on RP1 / RN1 (replicas of OP / ON)
XRP2 vabp vabp dabp vdd sky130_fd_pr__pfet_g5v0d10v5 W=5 L=0.6
XRP1 dabp dabp vdd vdd sky130_fd_pr__pfet_g5v0d10v5 W=10 L=0.5
XRN2 vabn vabn dabn vss sky130_fd_pr__nfet_g5v0d10v5 W=5 L=1
XRN1 dabn dabn vss vss sky130_fd_pr__nfet_g5v0d10v5 W=5 L=1
* --- output devices (vddo = vdd, vsso = vss)
XOP vout a vdd vdd sky130_fd_pr__pfet_g5v0d10v5 W=10 L=0.5 m={mop}
XON vout b vss vss sky130_fd_pr__nfet_g5v0d10v5 W=5 L=1 m={mon}
* --- Miller capacitors (MIM)
XCMA a vout sky130_fd_pr__cap_mim_m3_1 w={wcm} l={wcm}
XCMB b vout sky130_fd_pr__cap_mim_m3_1 w={wcm} l={wcm}
.ends d2s_mpdda_sky130

.subckt d2s_core_sky130 vdd vss vinp vinn vref pad iref wcm=25 mop=40 mon=40
Xb vdd vss iref vbp vbn vbpc vbnc vabp vabn d2s_bias_sky130
Xa vdd vss vinp vinn vref pad pad vbp vbn vbpc vbnc vabp vabn d2s_mpdda_sky130 wcm={wcm} mop={mop} mon={mon}
.ends d2s_core_sky130
