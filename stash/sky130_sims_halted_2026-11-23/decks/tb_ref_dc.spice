* SPDX-FileCopyrightText: 2026 Christoph Maier
* SPDX-License-Identifier: Apache-2.0
*
* tb_ref_dc: DC characterization of a reference-current core (bg_core_sky130 or
* oa_core_sky130) at one model-library section (@CORNER@).
* Template: scripts/run_sims.py replaces @PDK_ROOT@ @PDK@ @CORNER@ @OUT@ @NETLIST@ @DUT@
* and @CHECKNODES@ (internal node voltages saved so that summarize.py can reject
* non-physical DC points, see the note in netlists/bg_core_sky130.spice).
*
* Load: iout sources into an ideal 0.7 V source (Vload); iout = i(Vload) (current into its + node).
* Enable: en_3v3 = vdd, en_3v3_b = 0 V (both via voltage sources that follow vdd).
* Analyses:
*   1) temperature sweep -40..125 C (5 C step) at vdd = 3.0 / 3.3 / 3.6 V, run upward
*      (_temp_*) and downward (_tempdn_*); summarize.py cross-checks the two (a DC sweep
*      can jump between solutions; the start-up itself is checked by tb_ref_tran)
*   2) supply sweep 0..3.6 V (10 mV) at -40 / 27 / 125 C
*   3) disabled (en_3v3 = 0, en_3v3_b = vdd) operating point at 3.6 V, -40 / 27 / 125 C
.lib @PDK_ROOT@/@PDK@/libs.tech/ngspice/sky130.lib.spice @CORNER@
.include @NETLIST@
* 1 Tohm from every node to ground: numerical aid only (<= 3.6 pA per node); it removed
* a silent DC-sweep glitch (a non-physical point accepted by ngspice) seen without it.
.option rshunt=1e12

Vvdd  vdd 0 3.3
Ben   en  0 V = V(vdd)*V(ensel)
Benb  enb 0 V = V(vdd)*(1-V(ensel))
Vensel ensel 0 1
Vload iout 0 0.7
XDUT vdd 0 iout en enb @DUT@

.control
set wr_singlescale
set wr_vecnames
* ---- 1) temperature sweeps
alter Vvdd dc = 3.0
dc temp -40 125 5
let iout = i(Vload)
let idd = -i(Vvdd)
wrdata @OUT@_temp_v3p0.txt iout idd @CHECKNODES@
dc temp 125 -40 -5
let iout = i(Vload)
let idd = -i(Vvdd)
wrdata @OUT@_tempdn_v3p0.txt iout idd @CHECKNODES@
alter Vvdd dc = 3.3
dc temp -40 125 5
let iout = i(Vload)
let idd = -i(Vvdd)
wrdata @OUT@_temp_v3p3.txt iout idd @CHECKNODES@
dc temp 125 -40 -5
let iout = i(Vload)
let idd = -i(Vvdd)
wrdata @OUT@_tempdn_v3p3.txt iout idd @CHECKNODES@
alter Vvdd dc = 3.6
dc temp -40 125 5
let iout = i(Vload)
let idd = -i(Vvdd)
wrdata @OUT@_temp_v3p6.txt iout idd @CHECKNODES@
dc temp 125 -40 -5
let iout = i(Vload)
let idd = -i(Vvdd)
wrdata @OUT@_tempdn_v3p6.txt iout idd @CHECKNODES@
* ---- 2) supply sweeps
option temp = -40
dc Vvdd 0 3.6 0.01
let iout = i(Vload)
wrdata @OUT@_vdd_tm40.txt iout @CHECKNODES@
option temp = 27
dc Vvdd 0 3.6 0.01
let iout = i(Vload)
wrdata @OUT@_vdd_t27.txt iout @CHECKNODES@
option temp = 125
dc Vvdd 0 3.6 0.01
let iout = i(Vload)
wrdata @OUT@_vdd_t125.txt iout @CHECKNODES@
* ---- 3) disabled state at 3.6 V
alter Vvdd dc = 3.6
alter Vensel dc = 0
option temp = -40
op
let iout = i(Vload)
let idd = -i(Vvdd)
echo "RESULT dis_iout_tm40 = $&iout"
echo "RESULT dis_idd_tm40 = $&idd"
option temp = 27
op
let iout = i(Vload)
let idd = -i(Vvdd)
echo "RESULT dis_iout_t27 = $&iout"
echo "RESULT dis_idd_t27 = $&idd"
option temp = 125
op
let iout = i(Vload)
let idd = -i(Vvdd)
echo "RESULT dis_iout_t125 = $&iout"
echo "RESULT dis_idd_t125 = $&idd"
.endc
.end
